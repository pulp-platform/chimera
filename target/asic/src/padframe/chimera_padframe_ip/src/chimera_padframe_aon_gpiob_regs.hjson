
{
    # File auto-generated by Padrick unknown
    name: "chimera_padframe_aon_gpiob_config"
    clock_primary: "clk_i"
    reset_primary: "rst_ni"
    bus_interfaces: [
        { protocol: "reg_iface", direction: "device"}
    ]
    regwidth: 32,
    registers: [
        {skipto: "0x108"},
        {
            name: INFO
            desc: "Read-only IP Information register"
            swaccess: "ro"
            hwaccess: "hro"
            fields: [
              {
                bits: "15:0"
                name: HW_VERSION
                desc: "Hardware version ID."
                resval: 2
              },
              {
                  bits:"31:16"
                  name: PADCOUNT
                  desc: "The number of muxable pads in this IP."
                  resval: "16"
              }
            ]
        }
      {
          name: GPIO_0_CFG
          desc: '''
            Pad signal configuration.
          '''
          swaccess: "rw"
          fields: [
            {
                bits: "0"
                name: chip2pad
                desc: '''
                     The signal that connects to the pads TX driver
                '''
                swaccess: "rw"
                hwaccess: "hro"
                resval: "1"
            },
            {
                bits: "1"
                name: output_en
                desc: '''
                     Enables the output driver of the pad
                '''
                swaccess: "rw"
                hwaccess: "hro"
                resval: "0"
            },
            {
                bits: "2"
                name: rx_en
                desc: '''
                     Input buffer enable
                '''
                swaccess: "rw"
                hwaccess: "hro"
                resval: "0"
            },
          ]
      }

       {
          name: GPIO_0_MUX_SEL
          desc: '''
              Pad signal port multiplex selection for pad gpio_0. The programmed value defines which port
              is connected to the pad.
          '''
          swaccess: "rw"
          hwaccess: "hro"
          resval: 0
          fields: [
              {
                  bits: "4:0"
                  enum: [
                      { value: "0", name: "register", desc: "Connects the Pad to the internal configuration register."}
                      { value: "1", name: "port_GPIOB0_gpio0", desc: "Connect port gpio0 from port group GPIOB0 to this pad." }
                      { value: "2", name: "port_GPIOB1_gpio0", desc: "Connect port gpio0 from port group GPIOB1 to this pad." }
                      { value: "3", name: "port_GPIOB2_gpio0", desc: "Connect port gpio0 from port group GPIOB2 to this pad." }
                      { value: "4", name: "port_GPIOB3_gpio0", desc: "Connect port gpio0 from port group GPIOB3 to this pad." }
                      { value: "5", name: "port_GPIOB4_gpio0", desc: "Connect port gpio0 from port group GPIOB4 to this pad." }
                      { value: "6", name: "port_GPIOB5_gpio0", desc: "Connect port gpio0 from port group GPIOB5 to this pad." }
                      { value: "7", name: "port_GPIOB6_gpio0", desc: "Connect port gpio0 from port group GPIOB6 to this pad." }
                      { value: "8", name: "port_GPIOB7_gpio0", desc: "Connect port gpio0 from port group GPIOB7 to this pad." }
                      { value: "9", name: "port_GPIOB8_gpio0", desc: "Connect port gpio0 from port group GPIOB8 to this pad." }
                      { value: "10", name: "port_GPIOB9_gpio0", desc: "Connect port gpio0 from port group GPIOB9 to this pad." }
                      { value: "11", name: "port_GPIOB10_gpio0", desc: "Connect port gpio0 from port group GPIOB10 to this pad." }
                      { value: "12", name: "port_GPIOB11_gpio0", desc: "Connect port gpio0 from port group GPIOB11 to this pad." }
                      { value: "13", name: "port_GPIOB12_gpio0", desc: "Connect port gpio0 from port group GPIOB12 to this pad." }
                      { value: "14", name: "port_GPIOB13_gpio0", desc: "Connect port gpio0 from port group GPIOB13 to this pad." }
                      { value: "15", name: "port_GPIOB14_gpio0", desc: "Connect port gpio0 from port group GPIOB14 to this pad." }
                      { value: "16", name: "port_GPIOB15_gpio0", desc: "Connect port gpio0 from port group GPIOB15 to this pad." }
                      { value: "17", name: "port_i2c_0_scl0", desc: "Connect port scl0 from port group i2c_0 to this pad." }
                      { value: "18", name: "port_i2c_0_sda0", desc: "Connect port sda0 from port group i2c_0 to this pad." }
                      { value: "19", name: "port_spi_csn", desc: "Connect port csn from port group spi to this pad." }
                      { value: "20", name: "port_spi_miso", desc: "Connect port miso from port group spi to this pad." }
                      { value: "21", name: "port_spi_mosi", desc: "Connect port mosi from port group spi to this pad." }
                      { value: "22", name: "port_spi_sck", desc: "Connect port sck from port group spi to this pad." }
                  ]
              }
          ]
      }

      {
          name: GPIO_1_CFG
          desc: '''
            Pad signal configuration.
          '''
          swaccess: "rw"
          fields: [
            {
                bits: "0"
                name: chip2pad
                desc: '''
                     The signal that connects to the pads TX driver
                '''
                swaccess: "rw"
                hwaccess: "hro"
                resval: "1"
            },
            {
                bits: "1"
                name: output_en
                desc: '''
                     Enables the output driver of the pad
                '''
                swaccess: "rw"
                hwaccess: "hro"
                resval: "0"
            },
            {
                bits: "2"
                name: rx_en
                desc: '''
                     Input buffer enable
                '''
                swaccess: "rw"
                hwaccess: "hro"
                resval: "0"
            },
          ]
      }

       {
          name: GPIO_1_MUX_SEL
          desc: '''
              Pad signal port multiplex selection for pad gpio_1. The programmed value defines which port
              is connected to the pad.
          '''
          swaccess: "rw"
          hwaccess: "hro"
          resval: 0
          fields: [
              {
                  bits: "4:0"
                  enum: [
                      { value: "0", name: "register", desc: "Connects the Pad to the internal configuration register."}
                      { value: "1", name: "port_GPIOB0_gpio0", desc: "Connect port gpio0 from port group GPIOB0 to this pad." }
                      { value: "2", name: "port_GPIOB1_gpio0", desc: "Connect port gpio0 from port group GPIOB1 to this pad." }
                      { value: "3", name: "port_GPIOB2_gpio0", desc: "Connect port gpio0 from port group GPIOB2 to this pad." }
                      { value: "4", name: "port_GPIOB3_gpio0", desc: "Connect port gpio0 from port group GPIOB3 to this pad." }
                      { value: "5", name: "port_GPIOB4_gpio0", desc: "Connect port gpio0 from port group GPIOB4 to this pad." }
                      { value: "6", name: "port_GPIOB5_gpio0", desc: "Connect port gpio0 from port group GPIOB5 to this pad." }
                      { value: "7", name: "port_GPIOB6_gpio0", desc: "Connect port gpio0 from port group GPIOB6 to this pad." }
                      { value: "8", name: "port_GPIOB7_gpio0", desc: "Connect port gpio0 from port group GPIOB7 to this pad." }
                      { value: "9", name: "port_GPIOB8_gpio0", desc: "Connect port gpio0 from port group GPIOB8 to this pad." }
                      { value: "10", name: "port_GPIOB9_gpio0", desc: "Connect port gpio0 from port group GPIOB9 to this pad." }
                      { value: "11", name: "port_GPIOB10_gpio0", desc: "Connect port gpio0 from port group GPIOB10 to this pad." }
                      { value: "12", name: "port_GPIOB11_gpio0", desc: "Connect port gpio0 from port group GPIOB11 to this pad." }
                      { value: "13", name: "port_GPIOB12_gpio0", desc: "Connect port gpio0 from port group GPIOB12 to this pad." }
                      { value: "14", name: "port_GPIOB13_gpio0", desc: "Connect port gpio0 from port group GPIOB13 to this pad." }
                      { value: "15", name: "port_GPIOB14_gpio0", desc: "Connect port gpio0 from port group GPIOB14 to this pad." }
                      { value: "16", name: "port_GPIOB15_gpio0", desc: "Connect port gpio0 from port group GPIOB15 to this pad." }
                      { value: "17", name: "port_i2c_0_scl0", desc: "Connect port scl0 from port group i2c_0 to this pad." }
                      { value: "18", name: "port_i2c_0_sda0", desc: "Connect port sda0 from port group i2c_0 to this pad." }
                      { value: "19", name: "port_spi_csn", desc: "Connect port csn from port group spi to this pad." }
                      { value: "20", name: "port_spi_miso", desc: "Connect port miso from port group spi to this pad." }
                      { value: "21", name: "port_spi_mosi", desc: "Connect port mosi from port group spi to this pad." }
                      { value: "22", name: "port_spi_sck", desc: "Connect port sck from port group spi to this pad." }
                  ]
              }
          ]
      }

      {
          name: GPIO_2_CFG
          desc: '''
            Pad signal configuration.
          '''
          swaccess: "rw"
          fields: [
            {
                bits: "0"
                name: chip2pad
                desc: '''
                     The signal that connects to the pads TX driver
                '''
                swaccess: "rw"
                hwaccess: "hro"
                resval: "1"
            },
            {
                bits: "1"
                name: output_en
                desc: '''
                     Enables the output driver of the pad
                '''
                swaccess: "rw"
                hwaccess: "hro"
                resval: "0"
            },
            {
                bits: "2"
                name: rx_en
                desc: '''
                     Input buffer enable
                '''
                swaccess: "rw"
                hwaccess: "hro"
                resval: "0"
            },
          ]
      }

       {
          name: GPIO_2_MUX_SEL
          desc: '''
              Pad signal port multiplex selection for pad gpio_2. The programmed value defines which port
              is connected to the pad.
          '''
          swaccess: "rw"
          hwaccess: "hro"
          resval: 0
          fields: [
              {
                  bits: "4:0"
                  enum: [
                      { value: "0", name: "register", desc: "Connects the Pad to the internal configuration register."}
                      { value: "1", name: "port_GPIOB0_gpio0", desc: "Connect port gpio0 from port group GPIOB0 to this pad." }
                      { value: "2", name: "port_GPIOB1_gpio0", desc: "Connect port gpio0 from port group GPIOB1 to this pad." }
                      { value: "3", name: "port_GPIOB2_gpio0", desc: "Connect port gpio0 from port group GPIOB2 to this pad." }
                      { value: "4", name: "port_GPIOB3_gpio0", desc: "Connect port gpio0 from port group GPIOB3 to this pad." }
                      { value: "5", name: "port_GPIOB4_gpio0", desc: "Connect port gpio0 from port group GPIOB4 to this pad." }
                      { value: "6", name: "port_GPIOB5_gpio0", desc: "Connect port gpio0 from port group GPIOB5 to this pad." }
                      { value: "7", name: "port_GPIOB6_gpio0", desc: "Connect port gpio0 from port group GPIOB6 to this pad." }
                      { value: "8", name: "port_GPIOB7_gpio0", desc: "Connect port gpio0 from port group GPIOB7 to this pad." }
                      { value: "9", name: "port_GPIOB8_gpio0", desc: "Connect port gpio0 from port group GPIOB8 to this pad." }
                      { value: "10", name: "port_GPIOB9_gpio0", desc: "Connect port gpio0 from port group GPIOB9 to this pad." }
                      { value: "11", name: "port_GPIOB10_gpio0", desc: "Connect port gpio0 from port group GPIOB10 to this pad." }
                      { value: "12", name: "port_GPIOB11_gpio0", desc: "Connect port gpio0 from port group GPIOB11 to this pad." }
                      { value: "13", name: "port_GPIOB12_gpio0", desc: "Connect port gpio0 from port group GPIOB12 to this pad." }
                      { value: "14", name: "port_GPIOB13_gpio0", desc: "Connect port gpio0 from port group GPIOB13 to this pad." }
                      { value: "15", name: "port_GPIOB14_gpio0", desc: "Connect port gpio0 from port group GPIOB14 to this pad." }
                      { value: "16", name: "port_GPIOB15_gpio0", desc: "Connect port gpio0 from port group GPIOB15 to this pad." }
                      { value: "17", name: "port_i2c_0_scl0", desc: "Connect port scl0 from port group i2c_0 to this pad." }
                      { value: "18", name: "port_i2c_0_sda0", desc: "Connect port sda0 from port group i2c_0 to this pad." }
                      { value: "19", name: "port_spi_csn", desc: "Connect port csn from port group spi to this pad." }
                      { value: "20", name: "port_spi_miso", desc: "Connect port miso from port group spi to this pad." }
                      { value: "21", name: "port_spi_mosi", desc: "Connect port mosi from port group spi to this pad." }
                      { value: "22", name: "port_spi_sck", desc: "Connect port sck from port group spi to this pad." }
                  ]
              }
          ]
      }

      {
          name: GPIO_3_CFG
          desc: '''
            Pad signal configuration.
          '''
          swaccess: "rw"
          fields: [
            {
                bits: "0"
                name: chip2pad
                desc: '''
                     The signal that connects to the pads TX driver
                '''
                swaccess: "rw"
                hwaccess: "hro"
                resval: "1"
            },
            {
                bits: "1"
                name: output_en
                desc: '''
                     Enables the output driver of the pad
                '''
                swaccess: "rw"
                hwaccess: "hro"
                resval: "0"
            },
            {
                bits: "2"
                name: rx_en
                desc: '''
                     Input buffer enable
                '''
                swaccess: "rw"
                hwaccess: "hro"
                resval: "0"
            },
          ]
      }

       {
          name: GPIO_3_MUX_SEL
          desc: '''
              Pad signal port multiplex selection for pad gpio_3. The programmed value defines which port
              is connected to the pad.
          '''
          swaccess: "rw"
          hwaccess: "hro"
          resval: 0
          fields: [
              {
                  bits: "4:0"
                  enum: [
                      { value: "0", name: "register", desc: "Connects the Pad to the internal configuration register."}
                      { value: "1", name: "port_GPIOB0_gpio0", desc: "Connect port gpio0 from port group GPIOB0 to this pad." }
                      { value: "2", name: "port_GPIOB1_gpio0", desc: "Connect port gpio0 from port group GPIOB1 to this pad." }
                      { value: "3", name: "port_GPIOB2_gpio0", desc: "Connect port gpio0 from port group GPIOB2 to this pad." }
                      { value: "4", name: "port_GPIOB3_gpio0", desc: "Connect port gpio0 from port group GPIOB3 to this pad." }
                      { value: "5", name: "port_GPIOB4_gpio0", desc: "Connect port gpio0 from port group GPIOB4 to this pad." }
                      { value: "6", name: "port_GPIOB5_gpio0", desc: "Connect port gpio0 from port group GPIOB5 to this pad." }
                      { value: "7", name: "port_GPIOB6_gpio0", desc: "Connect port gpio0 from port group GPIOB6 to this pad." }
                      { value: "8", name: "port_GPIOB7_gpio0", desc: "Connect port gpio0 from port group GPIOB7 to this pad." }
                      { value: "9", name: "port_GPIOB8_gpio0", desc: "Connect port gpio0 from port group GPIOB8 to this pad." }
                      { value: "10", name: "port_GPIOB9_gpio0", desc: "Connect port gpio0 from port group GPIOB9 to this pad." }
                      { value: "11", name: "port_GPIOB10_gpio0", desc: "Connect port gpio0 from port group GPIOB10 to this pad." }
                      { value: "12", name: "port_GPIOB11_gpio0", desc: "Connect port gpio0 from port group GPIOB11 to this pad." }
                      { value: "13", name: "port_GPIOB12_gpio0", desc: "Connect port gpio0 from port group GPIOB12 to this pad." }
                      { value: "14", name: "port_GPIOB13_gpio0", desc: "Connect port gpio0 from port group GPIOB13 to this pad." }
                      { value: "15", name: "port_GPIOB14_gpio0", desc: "Connect port gpio0 from port group GPIOB14 to this pad." }
                      { value: "16", name: "port_GPIOB15_gpio0", desc: "Connect port gpio0 from port group GPIOB15 to this pad." }
                      { value: "17", name: "port_i2c_0_scl0", desc: "Connect port scl0 from port group i2c_0 to this pad." }
                      { value: "18", name: "port_i2c_0_sda0", desc: "Connect port sda0 from port group i2c_0 to this pad." }
                      { value: "19", name: "port_spi_csn", desc: "Connect port csn from port group spi to this pad." }
                      { value: "20", name: "port_spi_miso", desc: "Connect port miso from port group spi to this pad." }
                      { value: "21", name: "port_spi_mosi", desc: "Connect port mosi from port group spi to this pad." }
                      { value: "22", name: "port_spi_sck", desc: "Connect port sck from port group spi to this pad." }
                  ]
              }
          ]
      }

      {
          name: GPIO_4_CFG
          desc: '''
            Pad signal configuration.
          '''
          swaccess: "rw"
          fields: [
            {
                bits: "0"
                name: chip2pad
                desc: '''
                     The signal that connects to the pads TX driver
                '''
                swaccess: "rw"
                hwaccess: "hro"
                resval: "1"
            },
            {
                bits: "1"
                name: output_en
                desc: '''
                     Enables the output driver of the pad
                '''
                swaccess: "rw"
                hwaccess: "hro"
                resval: "0"
            },
            {
                bits: "2"
                name: rx_en
                desc: '''
                     Input buffer enable
                '''
                swaccess: "rw"
                hwaccess: "hro"
                resval: "0"
            },
          ]
      }

       {
          name: GPIO_4_MUX_SEL
          desc: '''
              Pad signal port multiplex selection for pad gpio_4. The programmed value defines which port
              is connected to the pad.
          '''
          swaccess: "rw"
          hwaccess: "hro"
          resval: 0
          fields: [
              {
                  bits: "4:0"
                  enum: [
                      { value: "0", name: "register", desc: "Connects the Pad to the internal configuration register."}
                      { value: "1", name: "port_GPIOB0_gpio0", desc: "Connect port gpio0 from port group GPIOB0 to this pad." }
                      { value: "2", name: "port_GPIOB1_gpio0", desc: "Connect port gpio0 from port group GPIOB1 to this pad." }
                      { value: "3", name: "port_GPIOB2_gpio0", desc: "Connect port gpio0 from port group GPIOB2 to this pad." }
                      { value: "4", name: "port_GPIOB3_gpio0", desc: "Connect port gpio0 from port group GPIOB3 to this pad." }
                      { value: "5", name: "port_GPIOB4_gpio0", desc: "Connect port gpio0 from port group GPIOB4 to this pad." }
                      { value: "6", name: "port_GPIOB5_gpio0", desc: "Connect port gpio0 from port group GPIOB5 to this pad." }
                      { value: "7", name: "port_GPIOB6_gpio0", desc: "Connect port gpio0 from port group GPIOB6 to this pad." }
                      { value: "8", name: "port_GPIOB7_gpio0", desc: "Connect port gpio0 from port group GPIOB7 to this pad." }
                      { value: "9", name: "port_GPIOB8_gpio0", desc: "Connect port gpio0 from port group GPIOB8 to this pad." }
                      { value: "10", name: "port_GPIOB9_gpio0", desc: "Connect port gpio0 from port group GPIOB9 to this pad." }
                      { value: "11", name: "port_GPIOB10_gpio0", desc: "Connect port gpio0 from port group GPIOB10 to this pad." }
                      { value: "12", name: "port_GPIOB11_gpio0", desc: "Connect port gpio0 from port group GPIOB11 to this pad." }
                      { value: "13", name: "port_GPIOB12_gpio0", desc: "Connect port gpio0 from port group GPIOB12 to this pad." }
                      { value: "14", name: "port_GPIOB13_gpio0", desc: "Connect port gpio0 from port group GPIOB13 to this pad." }
                      { value: "15", name: "port_GPIOB14_gpio0", desc: "Connect port gpio0 from port group GPIOB14 to this pad." }
                      { value: "16", name: "port_GPIOB15_gpio0", desc: "Connect port gpio0 from port group GPIOB15 to this pad." }
                      { value: "17", name: "port_i2c_0_scl0", desc: "Connect port scl0 from port group i2c_0 to this pad." }
                      { value: "18", name: "port_i2c_0_sda0", desc: "Connect port sda0 from port group i2c_0 to this pad." }
                      { value: "19", name: "port_spi_csn", desc: "Connect port csn from port group spi to this pad." }
                      { value: "20", name: "port_spi_miso", desc: "Connect port miso from port group spi to this pad." }
                      { value: "21", name: "port_spi_mosi", desc: "Connect port mosi from port group spi to this pad." }
                      { value: "22", name: "port_spi_sck", desc: "Connect port sck from port group spi to this pad." }
                  ]
              }
          ]
      }

      {
          name: GPIO_5_CFG
          desc: '''
            Pad signal configuration.
          '''
          swaccess: "rw"
          fields: [
            {
                bits: "0"
                name: chip2pad
                desc: '''
                     The signal that connects to the pads TX driver
                '''
                swaccess: "rw"
                hwaccess: "hro"
                resval: "1"
            },
            {
                bits: "1"
                name: output_en
                desc: '''
                     Enables the output driver of the pad
                '''
                swaccess: "rw"
                hwaccess: "hro"
                resval: "0"
            },
            {
                bits: "2"
                name: rx_en
                desc: '''
                     Input buffer enable
                '''
                swaccess: "rw"
                hwaccess: "hro"
                resval: "0"
            },
          ]
      }

       {
          name: GPIO_5_MUX_SEL
          desc: '''
              Pad signal port multiplex selection for pad gpio_5. The programmed value defines which port
              is connected to the pad.
          '''
          swaccess: "rw"
          hwaccess: "hro"
          resval: 0
          fields: [
              {
                  bits: "4:0"
                  enum: [
                      { value: "0", name: "register", desc: "Connects the Pad to the internal configuration register."}
                      { value: "1", name: "port_GPIOB0_gpio0", desc: "Connect port gpio0 from port group GPIOB0 to this pad." }
                      { value: "2", name: "port_GPIOB1_gpio0", desc: "Connect port gpio0 from port group GPIOB1 to this pad." }
                      { value: "3", name: "port_GPIOB2_gpio0", desc: "Connect port gpio0 from port group GPIOB2 to this pad." }
                      { value: "4", name: "port_GPIOB3_gpio0", desc: "Connect port gpio0 from port group GPIOB3 to this pad." }
                      { value: "5", name: "port_GPIOB4_gpio0", desc: "Connect port gpio0 from port group GPIOB4 to this pad." }
                      { value: "6", name: "port_GPIOB5_gpio0", desc: "Connect port gpio0 from port group GPIOB5 to this pad." }
                      { value: "7", name: "port_GPIOB6_gpio0", desc: "Connect port gpio0 from port group GPIOB6 to this pad." }
                      { value: "8", name: "port_GPIOB7_gpio0", desc: "Connect port gpio0 from port group GPIOB7 to this pad." }
                      { value: "9", name: "port_GPIOB8_gpio0", desc: "Connect port gpio0 from port group GPIOB8 to this pad." }
                      { value: "10", name: "port_GPIOB9_gpio0", desc: "Connect port gpio0 from port group GPIOB9 to this pad." }
                      { value: "11", name: "port_GPIOB10_gpio0", desc: "Connect port gpio0 from port group GPIOB10 to this pad." }
                      { value: "12", name: "port_GPIOB11_gpio0", desc: "Connect port gpio0 from port group GPIOB11 to this pad." }
                      { value: "13", name: "port_GPIOB12_gpio0", desc: "Connect port gpio0 from port group GPIOB12 to this pad." }
                      { value: "14", name: "port_GPIOB13_gpio0", desc: "Connect port gpio0 from port group GPIOB13 to this pad." }
                      { value: "15", name: "port_GPIOB14_gpio0", desc: "Connect port gpio0 from port group GPIOB14 to this pad." }
                      { value: "16", name: "port_GPIOB15_gpio0", desc: "Connect port gpio0 from port group GPIOB15 to this pad." }
                      { value: "17", name: "port_i2c_0_scl0", desc: "Connect port scl0 from port group i2c_0 to this pad." }
                      { value: "18", name: "port_i2c_0_sda0", desc: "Connect port sda0 from port group i2c_0 to this pad." }
                      { value: "19", name: "port_spi_csn", desc: "Connect port csn from port group spi to this pad." }
                      { value: "20", name: "port_spi_miso", desc: "Connect port miso from port group spi to this pad." }
                      { value: "21", name: "port_spi_mosi", desc: "Connect port mosi from port group spi to this pad." }
                      { value: "22", name: "port_spi_sck", desc: "Connect port sck from port group spi to this pad." }
                  ]
              }
          ]
      }

      {
          name: GPIO_6_CFG
          desc: '''
            Pad signal configuration.
          '''
          swaccess: "rw"
          fields: [
            {
                bits: "0"
                name: chip2pad
                desc: '''
                     The signal that connects to the pads TX driver
                '''
                swaccess: "rw"
                hwaccess: "hro"
                resval: "1"
            },
            {
                bits: "1"
                name: output_en
                desc: '''
                     Enables the output driver of the pad
                '''
                swaccess: "rw"
                hwaccess: "hro"
                resval: "0"
            },
            {
                bits: "2"
                name: rx_en
                desc: '''
                     Input buffer enable
                '''
                swaccess: "rw"
                hwaccess: "hro"
                resval: "0"
            },
          ]
      }

       {
          name: GPIO_6_MUX_SEL
          desc: '''
              Pad signal port multiplex selection for pad gpio_6. The programmed value defines which port
              is connected to the pad.
          '''
          swaccess: "rw"
          hwaccess: "hro"
          resval: 0
          fields: [
              {
                  bits: "4:0"
                  enum: [
                      { value: "0", name: "register", desc: "Connects the Pad to the internal configuration register."}
                      { value: "1", name: "port_GPIOB0_gpio0", desc: "Connect port gpio0 from port group GPIOB0 to this pad." }
                      { value: "2", name: "port_GPIOB1_gpio0", desc: "Connect port gpio0 from port group GPIOB1 to this pad." }
                      { value: "3", name: "port_GPIOB2_gpio0", desc: "Connect port gpio0 from port group GPIOB2 to this pad." }
                      { value: "4", name: "port_GPIOB3_gpio0", desc: "Connect port gpio0 from port group GPIOB3 to this pad." }
                      { value: "5", name: "port_GPIOB4_gpio0", desc: "Connect port gpio0 from port group GPIOB4 to this pad." }
                      { value: "6", name: "port_GPIOB5_gpio0", desc: "Connect port gpio0 from port group GPIOB5 to this pad." }
                      { value: "7", name: "port_GPIOB6_gpio0", desc: "Connect port gpio0 from port group GPIOB6 to this pad." }
                      { value: "8", name: "port_GPIOB7_gpio0", desc: "Connect port gpio0 from port group GPIOB7 to this pad." }
                      { value: "9", name: "port_GPIOB8_gpio0", desc: "Connect port gpio0 from port group GPIOB8 to this pad." }
                      { value: "10", name: "port_GPIOB9_gpio0", desc: "Connect port gpio0 from port group GPIOB9 to this pad." }
                      { value: "11", name: "port_GPIOB10_gpio0", desc: "Connect port gpio0 from port group GPIOB10 to this pad." }
                      { value: "12", name: "port_GPIOB11_gpio0", desc: "Connect port gpio0 from port group GPIOB11 to this pad." }
                      { value: "13", name: "port_GPIOB12_gpio0", desc: "Connect port gpio0 from port group GPIOB12 to this pad." }
                      { value: "14", name: "port_GPIOB13_gpio0", desc: "Connect port gpio0 from port group GPIOB13 to this pad." }
                      { value: "15", name: "port_GPIOB14_gpio0", desc: "Connect port gpio0 from port group GPIOB14 to this pad." }
                      { value: "16", name: "port_GPIOB15_gpio0", desc: "Connect port gpio0 from port group GPIOB15 to this pad." }
                      { value: "17", name: "port_i2c_0_scl0", desc: "Connect port scl0 from port group i2c_0 to this pad." }
                      { value: "18", name: "port_i2c_0_sda0", desc: "Connect port sda0 from port group i2c_0 to this pad." }
                      { value: "19", name: "port_spi_csn", desc: "Connect port csn from port group spi to this pad." }
                      { value: "20", name: "port_spi_miso", desc: "Connect port miso from port group spi to this pad." }
                      { value: "21", name: "port_spi_mosi", desc: "Connect port mosi from port group spi to this pad." }
                      { value: "22", name: "port_spi_sck", desc: "Connect port sck from port group spi to this pad." }
                  ]
              }
          ]
      }

      {
          name: GPIO_7_CFG
          desc: '''
            Pad signal configuration.
          '''
          swaccess: "rw"
          fields: [
            {
                bits: "0"
                name: chip2pad
                desc: '''
                     The signal that connects to the pads TX driver
                '''
                swaccess: "rw"
                hwaccess: "hro"
                resval: "1"
            },
            {
                bits: "1"
                name: output_en
                desc: '''
                     Enables the output driver of the pad
                '''
                swaccess: "rw"
                hwaccess: "hro"
                resval: "0"
            },
            {
                bits: "2"
                name: rx_en
                desc: '''
                     Input buffer enable
                '''
                swaccess: "rw"
                hwaccess: "hro"
                resval: "0"
            },
          ]
      }

       {
          name: GPIO_7_MUX_SEL
          desc: '''
              Pad signal port multiplex selection for pad gpio_7. The programmed value defines which port
              is connected to the pad.
          '''
          swaccess: "rw"
          hwaccess: "hro"
          resval: 0
          fields: [
              {
                  bits: "4:0"
                  enum: [
                      { value: "0", name: "register", desc: "Connects the Pad to the internal configuration register."}
                      { value: "1", name: "port_GPIOB0_gpio0", desc: "Connect port gpio0 from port group GPIOB0 to this pad." }
                      { value: "2", name: "port_GPIOB1_gpio0", desc: "Connect port gpio0 from port group GPIOB1 to this pad." }
                      { value: "3", name: "port_GPIOB2_gpio0", desc: "Connect port gpio0 from port group GPIOB2 to this pad." }
                      { value: "4", name: "port_GPIOB3_gpio0", desc: "Connect port gpio0 from port group GPIOB3 to this pad." }
                      { value: "5", name: "port_GPIOB4_gpio0", desc: "Connect port gpio0 from port group GPIOB4 to this pad." }
                      { value: "6", name: "port_GPIOB5_gpio0", desc: "Connect port gpio0 from port group GPIOB5 to this pad." }
                      { value: "7", name: "port_GPIOB6_gpio0", desc: "Connect port gpio0 from port group GPIOB6 to this pad." }
                      { value: "8", name: "port_GPIOB7_gpio0", desc: "Connect port gpio0 from port group GPIOB7 to this pad." }
                      { value: "9", name: "port_GPIOB8_gpio0", desc: "Connect port gpio0 from port group GPIOB8 to this pad." }
                      { value: "10", name: "port_GPIOB9_gpio0", desc: "Connect port gpio0 from port group GPIOB9 to this pad." }
                      { value: "11", name: "port_GPIOB10_gpio0", desc: "Connect port gpio0 from port group GPIOB10 to this pad." }
                      { value: "12", name: "port_GPIOB11_gpio0", desc: "Connect port gpio0 from port group GPIOB11 to this pad." }
                      { value: "13", name: "port_GPIOB12_gpio0", desc: "Connect port gpio0 from port group GPIOB12 to this pad." }
                      { value: "14", name: "port_GPIOB13_gpio0", desc: "Connect port gpio0 from port group GPIOB13 to this pad." }
                      { value: "15", name: "port_GPIOB14_gpio0", desc: "Connect port gpio0 from port group GPIOB14 to this pad." }
                      { value: "16", name: "port_GPIOB15_gpio0", desc: "Connect port gpio0 from port group GPIOB15 to this pad." }
                      { value: "17", name: "port_i2c_0_scl0", desc: "Connect port scl0 from port group i2c_0 to this pad." }
                      { value: "18", name: "port_i2c_0_sda0", desc: "Connect port sda0 from port group i2c_0 to this pad." }
                      { value: "19", name: "port_spi_csn", desc: "Connect port csn from port group spi to this pad." }
                      { value: "20", name: "port_spi_miso", desc: "Connect port miso from port group spi to this pad." }
                      { value: "21", name: "port_spi_mosi", desc: "Connect port mosi from port group spi to this pad." }
                      { value: "22", name: "port_spi_sck", desc: "Connect port sck from port group spi to this pad." }
                  ]
              }
          ]
      }

      {
          name: GPIO_8_CFG
          desc: '''
            Pad signal configuration.
          '''
          swaccess: "rw"
          fields: [
            {
                bits: "0"
                name: chip2pad
                desc: '''
                     The signal that connects to the pads TX driver
                '''
                swaccess: "rw"
                hwaccess: "hro"
                resval: "1"
            },
            {
                bits: "1"
                name: output_en
                desc: '''
                     Enables the output driver of the pad
                '''
                swaccess: "rw"
                hwaccess: "hro"
                resval: "0"
            },
            {
                bits: "2"
                name: rx_en
                desc: '''
                     Input buffer enable
                '''
                swaccess: "rw"
                hwaccess: "hro"
                resval: "0"
            },
          ]
      }

       {
          name: GPIO_8_MUX_SEL
          desc: '''
              Pad signal port multiplex selection for pad gpio_8. The programmed value defines which port
              is connected to the pad.
          '''
          swaccess: "rw"
          hwaccess: "hro"
          resval: 0
          fields: [
              {
                  bits: "4:0"
                  enum: [
                      { value: "0", name: "register", desc: "Connects the Pad to the internal configuration register."}
                      { value: "1", name: "port_GPIOB0_gpio0", desc: "Connect port gpio0 from port group GPIOB0 to this pad." }
                      { value: "2", name: "port_GPIOB1_gpio0", desc: "Connect port gpio0 from port group GPIOB1 to this pad." }
                      { value: "3", name: "port_GPIOB2_gpio0", desc: "Connect port gpio0 from port group GPIOB2 to this pad." }
                      { value: "4", name: "port_GPIOB3_gpio0", desc: "Connect port gpio0 from port group GPIOB3 to this pad." }
                      { value: "5", name: "port_GPIOB4_gpio0", desc: "Connect port gpio0 from port group GPIOB4 to this pad." }
                      { value: "6", name: "port_GPIOB5_gpio0", desc: "Connect port gpio0 from port group GPIOB5 to this pad." }
                      { value: "7", name: "port_GPIOB6_gpio0", desc: "Connect port gpio0 from port group GPIOB6 to this pad." }
                      { value: "8", name: "port_GPIOB7_gpio0", desc: "Connect port gpio0 from port group GPIOB7 to this pad." }
                      { value: "9", name: "port_GPIOB8_gpio0", desc: "Connect port gpio0 from port group GPIOB8 to this pad." }
                      { value: "10", name: "port_GPIOB9_gpio0", desc: "Connect port gpio0 from port group GPIOB9 to this pad." }
                      { value: "11", name: "port_GPIOB10_gpio0", desc: "Connect port gpio0 from port group GPIOB10 to this pad." }
                      { value: "12", name: "port_GPIOB11_gpio0", desc: "Connect port gpio0 from port group GPIOB11 to this pad." }
                      { value: "13", name: "port_GPIOB12_gpio0", desc: "Connect port gpio0 from port group GPIOB12 to this pad." }
                      { value: "14", name: "port_GPIOB13_gpio0", desc: "Connect port gpio0 from port group GPIOB13 to this pad." }
                      { value: "15", name: "port_GPIOB14_gpio0", desc: "Connect port gpio0 from port group GPIOB14 to this pad." }
                      { value: "16", name: "port_GPIOB15_gpio0", desc: "Connect port gpio0 from port group GPIOB15 to this pad." }
                      { value: "17", name: "port_i2c_0_scl0", desc: "Connect port scl0 from port group i2c_0 to this pad." }
                      { value: "18", name: "port_i2c_0_sda0", desc: "Connect port sda0 from port group i2c_0 to this pad." }
                      { value: "19", name: "port_spi_csn", desc: "Connect port csn from port group spi to this pad." }
                      { value: "20", name: "port_spi_miso", desc: "Connect port miso from port group spi to this pad." }
                      { value: "21", name: "port_spi_mosi", desc: "Connect port mosi from port group spi to this pad." }
                      { value: "22", name: "port_spi_sck", desc: "Connect port sck from port group spi to this pad." }
                  ]
              }
          ]
      }

      {
          name: GPIO_9_CFG
          desc: '''
            Pad signal configuration.
          '''
          swaccess: "rw"
          fields: [
            {
                bits: "0"
                name: chip2pad
                desc: '''
                     The signal that connects to the pads TX driver
                '''
                swaccess: "rw"
                hwaccess: "hro"
                resval: "1"
            },
            {
                bits: "1"
                name: output_en
                desc: '''
                     Enables the output driver of the pad
                '''
                swaccess: "rw"
                hwaccess: "hro"
                resval: "0"
            },
            {
                bits: "2"
                name: rx_en
                desc: '''
                     Input buffer enable
                '''
                swaccess: "rw"
                hwaccess: "hro"
                resval: "0"
            },
          ]
      }

       {
          name: GPIO_9_MUX_SEL
          desc: '''
              Pad signal port multiplex selection for pad gpio_9. The programmed value defines which port
              is connected to the pad.
          '''
          swaccess: "rw"
          hwaccess: "hro"
          resval: 0
          fields: [
              {
                  bits: "4:0"
                  enum: [
                      { value: "0", name: "register", desc: "Connects the Pad to the internal configuration register."}
                      { value: "1", name: "port_GPIOB0_gpio0", desc: "Connect port gpio0 from port group GPIOB0 to this pad." }
                      { value: "2", name: "port_GPIOB1_gpio0", desc: "Connect port gpio0 from port group GPIOB1 to this pad." }
                      { value: "3", name: "port_GPIOB2_gpio0", desc: "Connect port gpio0 from port group GPIOB2 to this pad." }
                      { value: "4", name: "port_GPIOB3_gpio0", desc: "Connect port gpio0 from port group GPIOB3 to this pad." }
                      { value: "5", name: "port_GPIOB4_gpio0", desc: "Connect port gpio0 from port group GPIOB4 to this pad." }
                      { value: "6", name: "port_GPIOB5_gpio0", desc: "Connect port gpio0 from port group GPIOB5 to this pad." }
                      { value: "7", name: "port_GPIOB6_gpio0", desc: "Connect port gpio0 from port group GPIOB6 to this pad." }
                      { value: "8", name: "port_GPIOB7_gpio0", desc: "Connect port gpio0 from port group GPIOB7 to this pad." }
                      { value: "9", name: "port_GPIOB8_gpio0", desc: "Connect port gpio0 from port group GPIOB8 to this pad." }
                      { value: "10", name: "port_GPIOB9_gpio0", desc: "Connect port gpio0 from port group GPIOB9 to this pad." }
                      { value: "11", name: "port_GPIOB10_gpio0", desc: "Connect port gpio0 from port group GPIOB10 to this pad." }
                      { value: "12", name: "port_GPIOB11_gpio0", desc: "Connect port gpio0 from port group GPIOB11 to this pad." }
                      { value: "13", name: "port_GPIOB12_gpio0", desc: "Connect port gpio0 from port group GPIOB12 to this pad." }
                      { value: "14", name: "port_GPIOB13_gpio0", desc: "Connect port gpio0 from port group GPIOB13 to this pad." }
                      { value: "15", name: "port_GPIOB14_gpio0", desc: "Connect port gpio0 from port group GPIOB14 to this pad." }
                      { value: "16", name: "port_GPIOB15_gpio0", desc: "Connect port gpio0 from port group GPIOB15 to this pad." }
                      { value: "17", name: "port_i2c_0_scl0", desc: "Connect port scl0 from port group i2c_0 to this pad." }
                      { value: "18", name: "port_i2c_0_sda0", desc: "Connect port sda0 from port group i2c_0 to this pad." }
                      { value: "19", name: "port_spi_csn", desc: "Connect port csn from port group spi to this pad." }
                      { value: "20", name: "port_spi_miso", desc: "Connect port miso from port group spi to this pad." }
                      { value: "21", name: "port_spi_mosi", desc: "Connect port mosi from port group spi to this pad." }
                      { value: "22", name: "port_spi_sck", desc: "Connect port sck from port group spi to this pad." }
                  ]
              }
          ]
      }

      {
          name: GPIO_10_CFG
          desc: '''
            Pad signal configuration.
          '''
          swaccess: "rw"
          fields: [
            {
                bits: "0"
                name: chip2pad
                desc: '''
                     The signal that connects to the pads TX driver
                '''
                swaccess: "rw"
                hwaccess: "hro"
                resval: "1"
            },
            {
                bits: "1"
                name: output_en
                desc: '''
                     Enables the output driver of the pad
                '''
                swaccess: "rw"
                hwaccess: "hro"
                resval: "0"
            },
            {
                bits: "2"
                name: rx_en
                desc: '''
                     Input buffer enable
                '''
                swaccess: "rw"
                hwaccess: "hro"
                resval: "0"
            },
          ]
      }

       {
          name: GPIO_10_MUX_SEL
          desc: '''
              Pad signal port multiplex selection for pad gpio_10. The programmed value defines which port
              is connected to the pad.
          '''
          swaccess: "rw"
          hwaccess: "hro"
          resval: 0
          fields: [
              {
                  bits: "4:0"
                  enum: [
                      { value: "0", name: "register", desc: "Connects the Pad to the internal configuration register."}
                      { value: "1", name: "port_GPIOB0_gpio0", desc: "Connect port gpio0 from port group GPIOB0 to this pad." }
                      { value: "2", name: "port_GPIOB1_gpio0", desc: "Connect port gpio0 from port group GPIOB1 to this pad." }
                      { value: "3", name: "port_GPIOB2_gpio0", desc: "Connect port gpio0 from port group GPIOB2 to this pad." }
                      { value: "4", name: "port_GPIOB3_gpio0", desc: "Connect port gpio0 from port group GPIOB3 to this pad." }
                      { value: "5", name: "port_GPIOB4_gpio0", desc: "Connect port gpio0 from port group GPIOB4 to this pad." }
                      { value: "6", name: "port_GPIOB5_gpio0", desc: "Connect port gpio0 from port group GPIOB5 to this pad." }
                      { value: "7", name: "port_GPIOB6_gpio0", desc: "Connect port gpio0 from port group GPIOB6 to this pad." }
                      { value: "8", name: "port_GPIOB7_gpio0", desc: "Connect port gpio0 from port group GPIOB7 to this pad." }
                      { value: "9", name: "port_GPIOB8_gpio0", desc: "Connect port gpio0 from port group GPIOB8 to this pad." }
                      { value: "10", name: "port_GPIOB9_gpio0", desc: "Connect port gpio0 from port group GPIOB9 to this pad." }
                      { value: "11", name: "port_GPIOB10_gpio0", desc: "Connect port gpio0 from port group GPIOB10 to this pad." }
                      { value: "12", name: "port_GPIOB11_gpio0", desc: "Connect port gpio0 from port group GPIOB11 to this pad." }
                      { value: "13", name: "port_GPIOB12_gpio0", desc: "Connect port gpio0 from port group GPIOB12 to this pad." }
                      { value: "14", name: "port_GPIOB13_gpio0", desc: "Connect port gpio0 from port group GPIOB13 to this pad." }
                      { value: "15", name: "port_GPIOB14_gpio0", desc: "Connect port gpio0 from port group GPIOB14 to this pad." }
                      { value: "16", name: "port_GPIOB15_gpio0", desc: "Connect port gpio0 from port group GPIOB15 to this pad." }
                      { value: "17", name: "port_i2c_0_scl0", desc: "Connect port scl0 from port group i2c_0 to this pad." }
                      { value: "18", name: "port_i2c_0_sda0", desc: "Connect port sda0 from port group i2c_0 to this pad." }
                      { value: "19", name: "port_spi_csn", desc: "Connect port csn from port group spi to this pad." }
                      { value: "20", name: "port_spi_miso", desc: "Connect port miso from port group spi to this pad." }
                      { value: "21", name: "port_spi_mosi", desc: "Connect port mosi from port group spi to this pad." }
                      { value: "22", name: "port_spi_sck", desc: "Connect port sck from port group spi to this pad." }
                  ]
              }
          ]
      }

      {
          name: GPIO_11_CFG
          desc: '''
            Pad signal configuration.
          '''
          swaccess: "rw"
          fields: [
            {
                bits: "0"
                name: chip2pad
                desc: '''
                     The signal that connects to the pads TX driver
                '''
                swaccess: "rw"
                hwaccess: "hro"
                resval: "1"
            },
            {
                bits: "1"
                name: output_en
                desc: '''
                     Enables the output driver of the pad
                '''
                swaccess: "rw"
                hwaccess: "hro"
                resval: "0"
            },
            {
                bits: "2"
                name: rx_en
                desc: '''
                     Input buffer enable
                '''
                swaccess: "rw"
                hwaccess: "hro"
                resval: "0"
            },
          ]
      }

       {
          name: GPIO_11_MUX_SEL
          desc: '''
              Pad signal port multiplex selection for pad gpio_11. The programmed value defines which port
              is connected to the pad.
          '''
          swaccess: "rw"
          hwaccess: "hro"
          resval: 0
          fields: [
              {
                  bits: "4:0"
                  enum: [
                      { value: "0", name: "register", desc: "Connects the Pad to the internal configuration register."}
                      { value: "1", name: "port_GPIOB0_gpio0", desc: "Connect port gpio0 from port group GPIOB0 to this pad." }
                      { value: "2", name: "port_GPIOB1_gpio0", desc: "Connect port gpio0 from port group GPIOB1 to this pad." }
                      { value: "3", name: "port_GPIOB2_gpio0", desc: "Connect port gpio0 from port group GPIOB2 to this pad." }
                      { value: "4", name: "port_GPIOB3_gpio0", desc: "Connect port gpio0 from port group GPIOB3 to this pad." }
                      { value: "5", name: "port_GPIOB4_gpio0", desc: "Connect port gpio0 from port group GPIOB4 to this pad." }
                      { value: "6", name: "port_GPIOB5_gpio0", desc: "Connect port gpio0 from port group GPIOB5 to this pad." }
                      { value: "7", name: "port_GPIOB6_gpio0", desc: "Connect port gpio0 from port group GPIOB6 to this pad." }
                      { value: "8", name: "port_GPIOB7_gpio0", desc: "Connect port gpio0 from port group GPIOB7 to this pad." }
                      { value: "9", name: "port_GPIOB8_gpio0", desc: "Connect port gpio0 from port group GPIOB8 to this pad." }
                      { value: "10", name: "port_GPIOB9_gpio0", desc: "Connect port gpio0 from port group GPIOB9 to this pad." }
                      { value: "11", name: "port_GPIOB10_gpio0", desc: "Connect port gpio0 from port group GPIOB10 to this pad." }
                      { value: "12", name: "port_GPIOB11_gpio0", desc: "Connect port gpio0 from port group GPIOB11 to this pad." }
                      { value: "13", name: "port_GPIOB12_gpio0", desc: "Connect port gpio0 from port group GPIOB12 to this pad." }
                      { value: "14", name: "port_GPIOB13_gpio0", desc: "Connect port gpio0 from port group GPIOB13 to this pad." }
                      { value: "15", name: "port_GPIOB14_gpio0", desc: "Connect port gpio0 from port group GPIOB14 to this pad." }
                      { value: "16", name: "port_GPIOB15_gpio0", desc: "Connect port gpio0 from port group GPIOB15 to this pad." }
                      { value: "17", name: "port_i2c_0_scl0", desc: "Connect port scl0 from port group i2c_0 to this pad." }
                      { value: "18", name: "port_i2c_0_sda0", desc: "Connect port sda0 from port group i2c_0 to this pad." }
                      { value: "19", name: "port_spi_csn", desc: "Connect port csn from port group spi to this pad." }
                      { value: "20", name: "port_spi_miso", desc: "Connect port miso from port group spi to this pad." }
                      { value: "21", name: "port_spi_mosi", desc: "Connect port mosi from port group spi to this pad." }
                      { value: "22", name: "port_spi_sck", desc: "Connect port sck from port group spi to this pad." }
                  ]
              }
          ]
      }

      {
          name: GPIO_12_CFG
          desc: '''
            Pad signal configuration.
          '''
          swaccess: "rw"
          fields: [
            {
                bits: "0"
                name: chip2pad
                desc: '''
                     The signal that connects to the pads TX driver
                '''
                swaccess: "rw"
                hwaccess: "hro"
                resval: "1"
            },
            {
                bits: "1"
                name: output_en
                desc: '''
                     Enables the output driver of the pad
                '''
                swaccess: "rw"
                hwaccess: "hro"
                resval: "0"
            },
            {
                bits: "2"
                name: rx_en
                desc: '''
                     Input buffer enable
                '''
                swaccess: "rw"
                hwaccess: "hro"
                resval: "0"
            },
          ]
      }

       {
          name: GPIO_12_MUX_SEL
          desc: '''
              Pad signal port multiplex selection for pad gpio_12. The programmed value defines which port
              is connected to the pad.
          '''
          swaccess: "rw"
          hwaccess: "hro"
          resval: 0
          fields: [
              {
                  bits: "4:0"
                  enum: [
                      { value: "0", name: "register", desc: "Connects the Pad to the internal configuration register."}
                      { value: "1", name: "port_GPIOB0_gpio0", desc: "Connect port gpio0 from port group GPIOB0 to this pad." }
                      { value: "2", name: "port_GPIOB1_gpio0", desc: "Connect port gpio0 from port group GPIOB1 to this pad." }
                      { value: "3", name: "port_GPIOB2_gpio0", desc: "Connect port gpio0 from port group GPIOB2 to this pad." }
                      { value: "4", name: "port_GPIOB3_gpio0", desc: "Connect port gpio0 from port group GPIOB3 to this pad." }
                      { value: "5", name: "port_GPIOB4_gpio0", desc: "Connect port gpio0 from port group GPIOB4 to this pad." }
                      { value: "6", name: "port_GPIOB5_gpio0", desc: "Connect port gpio0 from port group GPIOB5 to this pad." }
                      { value: "7", name: "port_GPIOB6_gpio0", desc: "Connect port gpio0 from port group GPIOB6 to this pad." }
                      { value: "8", name: "port_GPIOB7_gpio0", desc: "Connect port gpio0 from port group GPIOB7 to this pad." }
                      { value: "9", name: "port_GPIOB8_gpio0", desc: "Connect port gpio0 from port group GPIOB8 to this pad." }
                      { value: "10", name: "port_GPIOB9_gpio0", desc: "Connect port gpio0 from port group GPIOB9 to this pad." }
                      { value: "11", name: "port_GPIOB10_gpio0", desc: "Connect port gpio0 from port group GPIOB10 to this pad." }
                      { value: "12", name: "port_GPIOB11_gpio0", desc: "Connect port gpio0 from port group GPIOB11 to this pad." }
                      { value: "13", name: "port_GPIOB12_gpio0", desc: "Connect port gpio0 from port group GPIOB12 to this pad." }
                      { value: "14", name: "port_GPIOB13_gpio0", desc: "Connect port gpio0 from port group GPIOB13 to this pad." }
                      { value: "15", name: "port_GPIOB14_gpio0", desc: "Connect port gpio0 from port group GPIOB14 to this pad." }
                      { value: "16", name: "port_GPIOB15_gpio0", desc: "Connect port gpio0 from port group GPIOB15 to this pad." }
                      { value: "17", name: "port_i2c_0_scl0", desc: "Connect port scl0 from port group i2c_0 to this pad." }
                      { value: "18", name: "port_i2c_0_sda0", desc: "Connect port sda0 from port group i2c_0 to this pad." }
                      { value: "19", name: "port_spi_csn", desc: "Connect port csn from port group spi to this pad." }
                      { value: "20", name: "port_spi_miso", desc: "Connect port miso from port group spi to this pad." }
                      { value: "21", name: "port_spi_mosi", desc: "Connect port mosi from port group spi to this pad." }
                      { value: "22", name: "port_spi_sck", desc: "Connect port sck from port group spi to this pad." }
                  ]
              }
          ]
      }

      {
          name: GPIO_13_CFG
          desc: '''
            Pad signal configuration.
          '''
          swaccess: "rw"
          fields: [
            {
                bits: "0"
                name: chip2pad
                desc: '''
                     The signal that connects to the pads TX driver
                '''
                swaccess: "rw"
                hwaccess: "hro"
                resval: "1"
            },
            {
                bits: "1"
                name: output_en
                desc: '''
                     Enables the output driver of the pad
                '''
                swaccess: "rw"
                hwaccess: "hro"
                resval: "0"
            },
            {
                bits: "2"
                name: rx_en
                desc: '''
                     Input buffer enable
                '''
                swaccess: "rw"
                hwaccess: "hro"
                resval: "0"
            },
          ]
      }

       {
          name: GPIO_13_MUX_SEL
          desc: '''
              Pad signal port multiplex selection for pad gpio_13. The programmed value defines which port
              is connected to the pad.
          '''
          swaccess: "rw"
          hwaccess: "hro"
          resval: 0
          fields: [
              {
                  bits: "4:0"
                  enum: [
                      { value: "0", name: "register", desc: "Connects the Pad to the internal configuration register."}
                      { value: "1", name: "port_GPIOB0_gpio0", desc: "Connect port gpio0 from port group GPIOB0 to this pad." }
                      { value: "2", name: "port_GPIOB1_gpio0", desc: "Connect port gpio0 from port group GPIOB1 to this pad." }
                      { value: "3", name: "port_GPIOB2_gpio0", desc: "Connect port gpio0 from port group GPIOB2 to this pad." }
                      { value: "4", name: "port_GPIOB3_gpio0", desc: "Connect port gpio0 from port group GPIOB3 to this pad." }
                      { value: "5", name: "port_GPIOB4_gpio0", desc: "Connect port gpio0 from port group GPIOB4 to this pad." }
                      { value: "6", name: "port_GPIOB5_gpio0", desc: "Connect port gpio0 from port group GPIOB5 to this pad." }
                      { value: "7", name: "port_GPIOB6_gpio0", desc: "Connect port gpio0 from port group GPIOB6 to this pad." }
                      { value: "8", name: "port_GPIOB7_gpio0", desc: "Connect port gpio0 from port group GPIOB7 to this pad." }
                      { value: "9", name: "port_GPIOB8_gpio0", desc: "Connect port gpio0 from port group GPIOB8 to this pad." }
                      { value: "10", name: "port_GPIOB9_gpio0", desc: "Connect port gpio0 from port group GPIOB9 to this pad." }
                      { value: "11", name: "port_GPIOB10_gpio0", desc: "Connect port gpio0 from port group GPIOB10 to this pad." }
                      { value: "12", name: "port_GPIOB11_gpio0", desc: "Connect port gpio0 from port group GPIOB11 to this pad." }
                      { value: "13", name: "port_GPIOB12_gpio0", desc: "Connect port gpio0 from port group GPIOB12 to this pad." }
                      { value: "14", name: "port_GPIOB13_gpio0", desc: "Connect port gpio0 from port group GPIOB13 to this pad." }
                      { value: "15", name: "port_GPIOB14_gpio0", desc: "Connect port gpio0 from port group GPIOB14 to this pad." }
                      { value: "16", name: "port_GPIOB15_gpio0", desc: "Connect port gpio0 from port group GPIOB15 to this pad." }
                      { value: "17", name: "port_i2c_0_scl0", desc: "Connect port scl0 from port group i2c_0 to this pad." }
                      { value: "18", name: "port_i2c_0_sda0", desc: "Connect port sda0 from port group i2c_0 to this pad." }
                      { value: "19", name: "port_spi_csn", desc: "Connect port csn from port group spi to this pad." }
                      { value: "20", name: "port_spi_miso", desc: "Connect port miso from port group spi to this pad." }
                      { value: "21", name: "port_spi_mosi", desc: "Connect port mosi from port group spi to this pad." }
                      { value: "22", name: "port_spi_sck", desc: "Connect port sck from port group spi to this pad." }
                  ]
              }
          ]
      }

      {
          name: GPIO_14_CFG
          desc: '''
            Pad signal configuration.
          '''
          swaccess: "rw"
          fields: [
            {
                bits: "0"
                name: chip2pad
                desc: '''
                     The signal that connects to the pads TX driver
                '''
                swaccess: "rw"
                hwaccess: "hro"
                resval: "1"
            },
            {
                bits: "1"
                name: output_en
                desc: '''
                     Enables the output driver of the pad
                '''
                swaccess: "rw"
                hwaccess: "hro"
                resval: "0"
            },
            {
                bits: "2"
                name: rx_en
                desc: '''
                     Input buffer enable
                '''
                swaccess: "rw"
                hwaccess: "hro"
                resval: "0"
            },
          ]
      }

       {
          name: GPIO_14_MUX_SEL
          desc: '''
              Pad signal port multiplex selection for pad gpio_14. The programmed value defines which port
              is connected to the pad.
          '''
          swaccess: "rw"
          hwaccess: "hro"
          resval: 0
          fields: [
              {
                  bits: "4:0"
                  enum: [
                      { value: "0", name: "register", desc: "Connects the Pad to the internal configuration register."}
                      { value: "1", name: "port_GPIOB0_gpio0", desc: "Connect port gpio0 from port group GPIOB0 to this pad." }
                      { value: "2", name: "port_GPIOB1_gpio0", desc: "Connect port gpio0 from port group GPIOB1 to this pad." }
                      { value: "3", name: "port_GPIOB2_gpio0", desc: "Connect port gpio0 from port group GPIOB2 to this pad." }
                      { value: "4", name: "port_GPIOB3_gpio0", desc: "Connect port gpio0 from port group GPIOB3 to this pad." }
                      { value: "5", name: "port_GPIOB4_gpio0", desc: "Connect port gpio0 from port group GPIOB4 to this pad." }
                      { value: "6", name: "port_GPIOB5_gpio0", desc: "Connect port gpio0 from port group GPIOB5 to this pad." }
                      { value: "7", name: "port_GPIOB6_gpio0", desc: "Connect port gpio0 from port group GPIOB6 to this pad." }
                      { value: "8", name: "port_GPIOB7_gpio0", desc: "Connect port gpio0 from port group GPIOB7 to this pad." }
                      { value: "9", name: "port_GPIOB8_gpio0", desc: "Connect port gpio0 from port group GPIOB8 to this pad." }
                      { value: "10", name: "port_GPIOB9_gpio0", desc: "Connect port gpio0 from port group GPIOB9 to this pad." }
                      { value: "11", name: "port_GPIOB10_gpio0", desc: "Connect port gpio0 from port group GPIOB10 to this pad." }
                      { value: "12", name: "port_GPIOB11_gpio0", desc: "Connect port gpio0 from port group GPIOB11 to this pad." }
                      { value: "13", name: "port_GPIOB12_gpio0", desc: "Connect port gpio0 from port group GPIOB12 to this pad." }
                      { value: "14", name: "port_GPIOB13_gpio0", desc: "Connect port gpio0 from port group GPIOB13 to this pad." }
                      { value: "15", name: "port_GPIOB14_gpio0", desc: "Connect port gpio0 from port group GPIOB14 to this pad." }
                      { value: "16", name: "port_GPIOB15_gpio0", desc: "Connect port gpio0 from port group GPIOB15 to this pad." }
                      { value: "17", name: "port_i2c_0_scl0", desc: "Connect port scl0 from port group i2c_0 to this pad." }
                      { value: "18", name: "port_i2c_0_sda0", desc: "Connect port sda0 from port group i2c_0 to this pad." }
                      { value: "19", name: "port_spi_csn", desc: "Connect port csn from port group spi to this pad." }
                      { value: "20", name: "port_spi_miso", desc: "Connect port miso from port group spi to this pad." }
                      { value: "21", name: "port_spi_mosi", desc: "Connect port mosi from port group spi to this pad." }
                      { value: "22", name: "port_spi_sck", desc: "Connect port sck from port group spi to this pad." }
                  ]
              }
          ]
      }

      {
          name: GPIO_15_CFG
          desc: '''
            Pad signal configuration.
          '''
          swaccess: "rw"
          fields: [
            {
                bits: "0"
                name: chip2pad
                desc: '''
                     The signal that connects to the pads TX driver
                '''
                swaccess: "rw"
                hwaccess: "hro"
                resval: "1"
            },
            {
                bits: "1"
                name: output_en
                desc: '''
                     Enables the output driver of the pad
                '''
                swaccess: "rw"
                hwaccess: "hro"
                resval: "0"
            },
            {
                bits: "2"
                name: rx_en
                desc: '''
                     Input buffer enable
                '''
                swaccess: "rw"
                hwaccess: "hro"
                resval: "0"
            },
          ]
      }

       {
          name: GPIO_15_MUX_SEL
          desc: '''
              Pad signal port multiplex selection for pad gpio_15. The programmed value defines which port
              is connected to the pad.
          '''
          swaccess: "rw"
          hwaccess: "hro"
          resval: 0
          fields: [
              {
                  bits: "4:0"
                  enum: [
                      { value: "0", name: "register", desc: "Connects the Pad to the internal configuration register."}
                      { value: "1", name: "port_GPIOB0_gpio0", desc: "Connect port gpio0 from port group GPIOB0 to this pad." }
                      { value: "2", name: "port_GPIOB1_gpio0", desc: "Connect port gpio0 from port group GPIOB1 to this pad." }
                      { value: "3", name: "port_GPIOB2_gpio0", desc: "Connect port gpio0 from port group GPIOB2 to this pad." }
                      { value: "4", name: "port_GPIOB3_gpio0", desc: "Connect port gpio0 from port group GPIOB3 to this pad." }
                      { value: "5", name: "port_GPIOB4_gpio0", desc: "Connect port gpio0 from port group GPIOB4 to this pad." }
                      { value: "6", name: "port_GPIOB5_gpio0", desc: "Connect port gpio0 from port group GPIOB5 to this pad." }
                      { value: "7", name: "port_GPIOB6_gpio0", desc: "Connect port gpio0 from port group GPIOB6 to this pad." }
                      { value: "8", name: "port_GPIOB7_gpio0", desc: "Connect port gpio0 from port group GPIOB7 to this pad." }
                      { value: "9", name: "port_GPIOB8_gpio0", desc: "Connect port gpio0 from port group GPIOB8 to this pad." }
                      { value: "10", name: "port_GPIOB9_gpio0", desc: "Connect port gpio0 from port group GPIOB9 to this pad." }
                      { value: "11", name: "port_GPIOB10_gpio0", desc: "Connect port gpio0 from port group GPIOB10 to this pad." }
                      { value: "12", name: "port_GPIOB11_gpio0", desc: "Connect port gpio0 from port group GPIOB11 to this pad." }
                      { value: "13", name: "port_GPIOB12_gpio0", desc: "Connect port gpio0 from port group GPIOB12 to this pad." }
                      { value: "14", name: "port_GPIOB13_gpio0", desc: "Connect port gpio0 from port group GPIOB13 to this pad." }
                      { value: "15", name: "port_GPIOB14_gpio0", desc: "Connect port gpio0 from port group GPIOB14 to this pad." }
                      { value: "16", name: "port_GPIOB15_gpio0", desc: "Connect port gpio0 from port group GPIOB15 to this pad." }
                      { value: "17", name: "port_i2c_0_scl0", desc: "Connect port scl0 from port group i2c_0 to this pad." }
                      { value: "18", name: "port_i2c_0_sda0", desc: "Connect port sda0 from port group i2c_0 to this pad." }
                      { value: "19", name: "port_spi_csn", desc: "Connect port csn from port group spi to this pad." }
                      { value: "20", name: "port_spi_miso", desc: "Connect port miso from port group spi to this pad." }
                      { value: "21", name: "port_spi_mosi", desc: "Connect port mosi from port group spi to this pad." }
                      { value: "22", name: "port_spi_sck", desc: "Connect port sck from port group spi to this pad." }
                  ]
              }
          ]
      }

    ]
}
