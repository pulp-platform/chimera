
{
    # File auto-generated by Padrick unknown
    name: "chimera_padframe_aon_gpioa_config"
    clock_primary: "clk_i"
    reset_primary: "rst_ni"
    bus_interfaces: [
        { protocol: "reg_iface", direction: "device"}
    ]
    regwidth: 32,
    registers: [
        {skipto: "0x4"},
        {
            name: INFO
            desc: "Read-only IP Information register"
            swaccess: "ro"
            hwaccess: "hro"
            fields: [
              {
                bits: "15:0"
                name: HW_VERSION
                desc: "Hardware version ID."
                resval: 2
              },
              {
                  bits:"31:16"
                  name: PADCOUNT
                  desc: "The number of muxable pads in this IP."
                  resval: "32"
              }
            ]
        }
      {
          name: GPIO_0_CFG
          desc: '''
            Pad signal configuration.
          '''
          swaccess: "rw"
          fields: [
            {
                bits: "0"
                name: chip2pad
                desc: '''
                     The signal that connects to the pads TX driver
                '''
                swaccess: "rw"
                hwaccess: "hro"
                resval: "1"
            },
            {
                bits: "1"
                name: output_en
                desc: '''
                     Enables the output driver of the pad
                '''
                swaccess: "rw"
                hwaccess: "hro"
                resval: "0"
            },
            {
                bits: "2"
                name: rx_en
                desc: '''
                     Input buffer enable
                '''
                swaccess: "rw"
                hwaccess: "hro"
                resval: "0"
            },
          ]
      }

       {
          name: GPIO_0_MUX_SEL
          desc: '''
              Pad signal port multiplex selection for pad gpio_0. The programmed value defines which port
              is connected to the pad.
          '''
          swaccess: "rw"
          hwaccess: "hro"
          resval: 0
          fields: [
              {
                  bits: "2:0"
                  enum: [
                      { value: "0", name: "register", desc: "Connects the Pad to the internal configuration register."}
                      { value: "1", name: "port_i2c_0_scl0", desc: "Connect port scl0 from port group i2c_0 to this pad." }
                      { value: "2", name: "port_i2c_0_sda0", desc: "Connect port sda0 from port group i2c_0 to this pad." }
                      { value: "3", name: "port_spi_csn", desc: "Connect port csn from port group spi to this pad." }
                      { value: "4", name: "port_spi_miso", desc: "Connect port miso from port group spi to this pad." }
                      { value: "5", name: "port_spi_mosi", desc: "Connect port mosi from port group spi to this pad." }
                      { value: "6", name: "port_spi_sck", desc: "Connect port sck from port group spi to this pad." }
                  ]
              }
          ]
      }

      {
          name: GPIO_1_CFG
          desc: '''
            Pad signal configuration.
          '''
          swaccess: "rw"
          fields: [
            {
                bits: "0"
                name: chip2pad
                desc: '''
                     The signal that connects to the pads TX driver
                '''
                swaccess: "rw"
                hwaccess: "hro"
                resval: "1"
            },
            {
                bits: "1"
                name: output_en
                desc: '''
                     Enables the output driver of the pad
                '''
                swaccess: "rw"
                hwaccess: "hro"
                resval: "0"
            },
            {
                bits: "2"
                name: rx_en
                desc: '''
                     Input buffer enable
                '''
                swaccess: "rw"
                hwaccess: "hro"
                resval: "0"
            },
          ]
      }

       {
          name: GPIO_1_MUX_SEL
          desc: '''
              Pad signal port multiplex selection for pad gpio_1. The programmed value defines which port
              is connected to the pad.
          '''
          swaccess: "rw"
          hwaccess: "hro"
          resval: 0
          fields: [
              {
                  bits: "2:0"
                  enum: [
                      { value: "0", name: "register", desc: "Connects the Pad to the internal configuration register."}
                      { value: "1", name: "port_i2c_0_scl0", desc: "Connect port scl0 from port group i2c_0 to this pad." }
                      { value: "2", name: "port_i2c_0_sda0", desc: "Connect port sda0 from port group i2c_0 to this pad." }
                      { value: "3", name: "port_spi_csn", desc: "Connect port csn from port group spi to this pad." }
                      { value: "4", name: "port_spi_miso", desc: "Connect port miso from port group spi to this pad." }
                      { value: "5", name: "port_spi_mosi", desc: "Connect port mosi from port group spi to this pad." }
                      { value: "6", name: "port_spi_sck", desc: "Connect port sck from port group spi to this pad." }
                  ]
              }
          ]
      }

      {
          name: GPIO_2_CFG
          desc: '''
            Pad signal configuration.
          '''
          swaccess: "rw"
          fields: [
            {
                bits: "0"
                name: chip2pad
                desc: '''
                     The signal that connects to the pads TX driver
                '''
                swaccess: "rw"
                hwaccess: "hro"
                resval: "1"
            },
            {
                bits: "1"
                name: output_en
                desc: '''
                     Enables the output driver of the pad
                '''
                swaccess: "rw"
                hwaccess: "hro"
                resval: "0"
            },
            {
                bits: "2"
                name: rx_en
                desc: '''
                     Input buffer enable
                '''
                swaccess: "rw"
                hwaccess: "hro"
                resval: "0"
            },
          ]
      }

       {
          name: GPIO_2_MUX_SEL
          desc: '''
              Pad signal port multiplex selection for pad gpio_2. The programmed value defines which port
              is connected to the pad.
          '''
          swaccess: "rw"
          hwaccess: "hro"
          resval: 0
          fields: [
              {
                  bits: "2:0"
                  enum: [
                      { value: "0", name: "register", desc: "Connects the Pad to the internal configuration register."}
                      { value: "1", name: "port_i2c_0_scl0", desc: "Connect port scl0 from port group i2c_0 to this pad." }
                      { value: "2", name: "port_i2c_0_sda0", desc: "Connect port sda0 from port group i2c_0 to this pad." }
                      { value: "3", name: "port_spi_csn", desc: "Connect port csn from port group spi to this pad." }
                      { value: "4", name: "port_spi_miso", desc: "Connect port miso from port group spi to this pad." }
                      { value: "5", name: "port_spi_mosi", desc: "Connect port mosi from port group spi to this pad." }
                      { value: "6", name: "port_spi_sck", desc: "Connect port sck from port group spi to this pad." }
                  ]
              }
          ]
      }

      {
          name: GPIO_3_CFG
          desc: '''
            Pad signal configuration.
          '''
          swaccess: "rw"
          fields: [
            {
                bits: "0"
                name: chip2pad
                desc: '''
                     The signal that connects to the pads TX driver
                '''
                swaccess: "rw"
                hwaccess: "hro"
                resval: "1"
            },
            {
                bits: "1"
                name: output_en
                desc: '''
                     Enables the output driver of the pad
                '''
                swaccess: "rw"
                hwaccess: "hro"
                resval: "0"
            },
            {
                bits: "2"
                name: rx_en
                desc: '''
                     Input buffer enable
                '''
                swaccess: "rw"
                hwaccess: "hro"
                resval: "0"
            },
          ]
      }

       {
          name: GPIO_3_MUX_SEL
          desc: '''
              Pad signal port multiplex selection for pad gpio_3. The programmed value defines which port
              is connected to the pad.
          '''
          swaccess: "rw"
          hwaccess: "hro"
          resval: 0
          fields: [
              {
                  bits: "2:0"
                  enum: [
                      { value: "0", name: "register", desc: "Connects the Pad to the internal configuration register."}
                      { value: "1", name: "port_i2c_0_scl0", desc: "Connect port scl0 from port group i2c_0 to this pad." }
                      { value: "2", name: "port_i2c_0_sda0", desc: "Connect port sda0 from port group i2c_0 to this pad." }
                      { value: "3", name: "port_spi_csn", desc: "Connect port csn from port group spi to this pad." }
                      { value: "4", name: "port_spi_miso", desc: "Connect port miso from port group spi to this pad." }
                      { value: "5", name: "port_spi_mosi", desc: "Connect port mosi from port group spi to this pad." }
                      { value: "6", name: "port_spi_sck", desc: "Connect port sck from port group spi to this pad." }
                  ]
              }
          ]
      }

      {
          name: GPIO_4_CFG
          desc: '''
            Pad signal configuration.
          '''
          swaccess: "rw"
          fields: [
            {
                bits: "0"
                name: chip2pad
                desc: '''
                     The signal that connects to the pads TX driver
                '''
                swaccess: "rw"
                hwaccess: "hro"
                resval: "1"
            },
            {
                bits: "1"
                name: output_en
                desc: '''
                     Enables the output driver of the pad
                '''
                swaccess: "rw"
                hwaccess: "hro"
                resval: "0"
            },
            {
                bits: "2"
                name: rx_en
                desc: '''
                     Input buffer enable
                '''
                swaccess: "rw"
                hwaccess: "hro"
                resval: "0"
            },
          ]
      }

       {
          name: GPIO_4_MUX_SEL
          desc: '''
              Pad signal port multiplex selection for pad gpio_4. The programmed value defines which port
              is connected to the pad.
          '''
          swaccess: "rw"
          hwaccess: "hro"
          resval: 0
          fields: [
              {
                  bits: "2:0"
                  enum: [
                      { value: "0", name: "register", desc: "Connects the Pad to the internal configuration register."}
                      { value: "1", name: "port_i2c_0_scl0", desc: "Connect port scl0 from port group i2c_0 to this pad." }
                      { value: "2", name: "port_i2c_0_sda0", desc: "Connect port sda0 from port group i2c_0 to this pad." }
                      { value: "3", name: "port_spi_csn", desc: "Connect port csn from port group spi to this pad." }
                      { value: "4", name: "port_spi_miso", desc: "Connect port miso from port group spi to this pad." }
                      { value: "5", name: "port_spi_mosi", desc: "Connect port mosi from port group spi to this pad." }
                      { value: "6", name: "port_spi_sck", desc: "Connect port sck from port group spi to this pad." }
                  ]
              }
          ]
      }

      {
          name: GPIO_5_CFG
          desc: '''
            Pad signal configuration.
          '''
          swaccess: "rw"
          fields: [
            {
                bits: "0"
                name: chip2pad
                desc: '''
                     The signal that connects to the pads TX driver
                '''
                swaccess: "rw"
                hwaccess: "hro"
                resval: "1"
            },
            {
                bits: "1"
                name: output_en
                desc: '''
                     Enables the output driver of the pad
                '''
                swaccess: "rw"
                hwaccess: "hro"
                resval: "0"
            },
            {
                bits: "2"
                name: rx_en
                desc: '''
                     Input buffer enable
                '''
                swaccess: "rw"
                hwaccess: "hro"
                resval: "0"
            },
          ]
      }

       {
          name: GPIO_5_MUX_SEL
          desc: '''
              Pad signal port multiplex selection for pad gpio_5. The programmed value defines which port
              is connected to the pad.
          '''
          swaccess: "rw"
          hwaccess: "hro"
          resval: 0
          fields: [
              {
                  bits: "2:0"
                  enum: [
                      { value: "0", name: "register", desc: "Connects the Pad to the internal configuration register."}
                      { value: "1", name: "port_i2c_0_scl0", desc: "Connect port scl0 from port group i2c_0 to this pad." }
                      { value: "2", name: "port_i2c_0_sda0", desc: "Connect port sda0 from port group i2c_0 to this pad." }
                      { value: "3", name: "port_spi_csn", desc: "Connect port csn from port group spi to this pad." }
                      { value: "4", name: "port_spi_miso", desc: "Connect port miso from port group spi to this pad." }
                      { value: "5", name: "port_spi_mosi", desc: "Connect port mosi from port group spi to this pad." }
                      { value: "6", name: "port_spi_sck", desc: "Connect port sck from port group spi to this pad." }
                  ]
              }
          ]
      }

      {
          name: GPIO_6_CFG
          desc: '''
            Pad signal configuration.
          '''
          swaccess: "rw"
          fields: [
            {
                bits: "0"
                name: chip2pad
                desc: '''
                     The signal that connects to the pads TX driver
                '''
                swaccess: "rw"
                hwaccess: "hro"
                resval: "1"
            },
            {
                bits: "1"
                name: output_en
                desc: '''
                     Enables the output driver of the pad
                '''
                swaccess: "rw"
                hwaccess: "hro"
                resval: "0"
            },
            {
                bits: "2"
                name: rx_en
                desc: '''
                     Input buffer enable
                '''
                swaccess: "rw"
                hwaccess: "hro"
                resval: "0"
            },
          ]
      }

       {
          name: GPIO_6_MUX_SEL
          desc: '''
              Pad signal port multiplex selection for pad gpio_6. The programmed value defines which port
              is connected to the pad.
          '''
          swaccess: "rw"
          hwaccess: "hro"
          resval: 0
          fields: [
              {
                  bits: "2:0"
                  enum: [
                      { value: "0", name: "register", desc: "Connects the Pad to the internal configuration register."}
                      { value: "1", name: "port_i2c_0_scl0", desc: "Connect port scl0 from port group i2c_0 to this pad." }
                      { value: "2", name: "port_i2c_0_sda0", desc: "Connect port sda0 from port group i2c_0 to this pad." }
                      { value: "3", name: "port_spi_csn", desc: "Connect port csn from port group spi to this pad." }
                      { value: "4", name: "port_spi_miso", desc: "Connect port miso from port group spi to this pad." }
                      { value: "5", name: "port_spi_mosi", desc: "Connect port mosi from port group spi to this pad." }
                      { value: "6", name: "port_spi_sck", desc: "Connect port sck from port group spi to this pad." }
                  ]
              }
          ]
      }

      {
          name: GPIO_7_CFG
          desc: '''
            Pad signal configuration.
          '''
          swaccess: "rw"
          fields: [
            {
                bits: "0"
                name: chip2pad
                desc: '''
                     The signal that connects to the pads TX driver
                '''
                swaccess: "rw"
                hwaccess: "hro"
                resval: "1"
            },
            {
                bits: "1"
                name: output_en
                desc: '''
                     Enables the output driver of the pad
                '''
                swaccess: "rw"
                hwaccess: "hro"
                resval: "0"
            },
            {
                bits: "2"
                name: rx_en
                desc: '''
                     Input buffer enable
                '''
                swaccess: "rw"
                hwaccess: "hro"
                resval: "0"
            },
          ]
      }

       {
          name: GPIO_7_MUX_SEL
          desc: '''
              Pad signal port multiplex selection for pad gpio_7. The programmed value defines which port
              is connected to the pad.
          '''
          swaccess: "rw"
          hwaccess: "hro"
          resval: 0
          fields: [
              {
                  bits: "2:0"
                  enum: [
                      { value: "0", name: "register", desc: "Connects the Pad to the internal configuration register."}
                      { value: "1", name: "port_i2c_0_scl0", desc: "Connect port scl0 from port group i2c_0 to this pad." }
                      { value: "2", name: "port_i2c_0_sda0", desc: "Connect port sda0 from port group i2c_0 to this pad." }
                      { value: "3", name: "port_spi_csn", desc: "Connect port csn from port group spi to this pad." }
                      { value: "4", name: "port_spi_miso", desc: "Connect port miso from port group spi to this pad." }
                      { value: "5", name: "port_spi_mosi", desc: "Connect port mosi from port group spi to this pad." }
                      { value: "6", name: "port_spi_sck", desc: "Connect port sck from port group spi to this pad." }
                  ]
              }
          ]
      }

      {
          name: GPIO_8_CFG
          desc: '''
            Pad signal configuration.
          '''
          swaccess: "rw"
          fields: [
            {
                bits: "0"
                name: chip2pad
                desc: '''
                     The signal that connects to the pads TX driver
                '''
                swaccess: "rw"
                hwaccess: "hro"
                resval: "1"
            },
            {
                bits: "1"
                name: output_en
                desc: '''
                     Enables the output driver of the pad
                '''
                swaccess: "rw"
                hwaccess: "hro"
                resval: "0"
            },
            {
                bits: "2"
                name: rx_en
                desc: '''
                     Input buffer enable
                '''
                swaccess: "rw"
                hwaccess: "hro"
                resval: "0"
            },
          ]
      }

       {
          name: GPIO_8_MUX_SEL
          desc: '''
              Pad signal port multiplex selection for pad gpio_8. The programmed value defines which port
              is connected to the pad.
          '''
          swaccess: "rw"
          hwaccess: "hro"
          resval: 0
          fields: [
              {
                  bits: "2:0"
                  enum: [
                      { value: "0", name: "register", desc: "Connects the Pad to the internal configuration register."}
                      { value: "1", name: "port_i2c_0_scl0", desc: "Connect port scl0 from port group i2c_0 to this pad." }
                      { value: "2", name: "port_i2c_0_sda0", desc: "Connect port sda0 from port group i2c_0 to this pad." }
                      { value: "3", name: "port_spi_csn", desc: "Connect port csn from port group spi to this pad." }
                      { value: "4", name: "port_spi_miso", desc: "Connect port miso from port group spi to this pad." }
                      { value: "5", name: "port_spi_mosi", desc: "Connect port mosi from port group spi to this pad." }
                      { value: "6", name: "port_spi_sck", desc: "Connect port sck from port group spi to this pad." }
                  ]
              }
          ]
      }

      {
          name: GPIO_9_CFG
          desc: '''
            Pad signal configuration.
          '''
          swaccess: "rw"
          fields: [
            {
                bits: "0"
                name: chip2pad
                desc: '''
                     The signal that connects to the pads TX driver
                '''
                swaccess: "rw"
                hwaccess: "hro"
                resval: "1"
            },
            {
                bits: "1"
                name: output_en
                desc: '''
                     Enables the output driver of the pad
                '''
                swaccess: "rw"
                hwaccess: "hro"
                resval: "0"
            },
            {
                bits: "2"
                name: rx_en
                desc: '''
                     Input buffer enable
                '''
                swaccess: "rw"
                hwaccess: "hro"
                resval: "0"
            },
          ]
      }

       {
          name: GPIO_9_MUX_SEL
          desc: '''
              Pad signal port multiplex selection for pad gpio_9. The programmed value defines which port
              is connected to the pad.
          '''
          swaccess: "rw"
          hwaccess: "hro"
          resval: 0
          fields: [
              {
                  bits: "2:0"
                  enum: [
                      { value: "0", name: "register", desc: "Connects the Pad to the internal configuration register."}
                      { value: "1", name: "port_i2c_0_scl0", desc: "Connect port scl0 from port group i2c_0 to this pad." }
                      { value: "2", name: "port_i2c_0_sda0", desc: "Connect port sda0 from port group i2c_0 to this pad." }
                      { value: "3", name: "port_spi_csn", desc: "Connect port csn from port group spi to this pad." }
                      { value: "4", name: "port_spi_miso", desc: "Connect port miso from port group spi to this pad." }
                      { value: "5", name: "port_spi_mosi", desc: "Connect port mosi from port group spi to this pad." }
                      { value: "6", name: "port_spi_sck", desc: "Connect port sck from port group spi to this pad." }
                  ]
              }
          ]
      }

      {
          name: GPIO_10_CFG
          desc: '''
            Pad signal configuration.
          '''
          swaccess: "rw"
          fields: [
            {
                bits: "0"
                name: chip2pad
                desc: '''
                     The signal that connects to the pads TX driver
                '''
                swaccess: "rw"
                hwaccess: "hro"
                resval: "1"
            },
            {
                bits: "1"
                name: output_en
                desc: '''
                     Enables the output driver of the pad
                '''
                swaccess: "rw"
                hwaccess: "hro"
                resval: "0"
            },
            {
                bits: "2"
                name: rx_en
                desc: '''
                     Input buffer enable
                '''
                swaccess: "rw"
                hwaccess: "hro"
                resval: "0"
            },
          ]
      }

       {
          name: GPIO_10_MUX_SEL
          desc: '''
              Pad signal port multiplex selection for pad gpio_10. The programmed value defines which port
              is connected to the pad.
          '''
          swaccess: "rw"
          hwaccess: "hro"
          resval: 0
          fields: [
              {
                  bits: "2:0"
                  enum: [
                      { value: "0", name: "register", desc: "Connects the Pad to the internal configuration register."}
                      { value: "1", name: "port_i2c_0_scl0", desc: "Connect port scl0 from port group i2c_0 to this pad." }
                      { value: "2", name: "port_i2c_0_sda0", desc: "Connect port sda0 from port group i2c_0 to this pad." }
                      { value: "3", name: "port_spi_csn", desc: "Connect port csn from port group spi to this pad." }
                      { value: "4", name: "port_spi_miso", desc: "Connect port miso from port group spi to this pad." }
                      { value: "5", name: "port_spi_mosi", desc: "Connect port mosi from port group spi to this pad." }
                      { value: "6", name: "port_spi_sck", desc: "Connect port sck from port group spi to this pad." }
                  ]
              }
          ]
      }

      {
          name: GPIO_11_CFG
          desc: '''
            Pad signal configuration.
          '''
          swaccess: "rw"
          fields: [
            {
                bits: "0"
                name: chip2pad
                desc: '''
                     The signal that connects to the pads TX driver
                '''
                swaccess: "rw"
                hwaccess: "hro"
                resval: "1"
            },
            {
                bits: "1"
                name: output_en
                desc: '''
                     Enables the output driver of the pad
                '''
                swaccess: "rw"
                hwaccess: "hro"
                resval: "0"
            },
            {
                bits: "2"
                name: rx_en
                desc: '''
                     Input buffer enable
                '''
                swaccess: "rw"
                hwaccess: "hro"
                resval: "0"
            },
          ]
      }

       {
          name: GPIO_11_MUX_SEL
          desc: '''
              Pad signal port multiplex selection for pad gpio_11. The programmed value defines which port
              is connected to the pad.
          '''
          swaccess: "rw"
          hwaccess: "hro"
          resval: 0
          fields: [
              {
                  bits: "2:0"
                  enum: [
                      { value: "0", name: "register", desc: "Connects the Pad to the internal configuration register."}
                      { value: "1", name: "port_i2c_0_scl0", desc: "Connect port scl0 from port group i2c_0 to this pad." }
                      { value: "2", name: "port_i2c_0_sda0", desc: "Connect port sda0 from port group i2c_0 to this pad." }
                      { value: "3", name: "port_spi_csn", desc: "Connect port csn from port group spi to this pad." }
                      { value: "4", name: "port_spi_miso", desc: "Connect port miso from port group spi to this pad." }
                      { value: "5", name: "port_spi_mosi", desc: "Connect port mosi from port group spi to this pad." }
                      { value: "6", name: "port_spi_sck", desc: "Connect port sck from port group spi to this pad." }
                  ]
              }
          ]
      }

      {
          name: GPIO_12_CFG
          desc: '''
            Pad signal configuration.
          '''
          swaccess: "rw"
          fields: [
            {
                bits: "0"
                name: chip2pad
                desc: '''
                     The signal that connects to the pads TX driver
                '''
                swaccess: "rw"
                hwaccess: "hro"
                resval: "1"
            },
            {
                bits: "1"
                name: output_en
                desc: '''
                     Enables the output driver of the pad
                '''
                swaccess: "rw"
                hwaccess: "hro"
                resval: "0"
            },
            {
                bits: "2"
                name: rx_en
                desc: '''
                     Input buffer enable
                '''
                swaccess: "rw"
                hwaccess: "hro"
                resval: "0"
            },
          ]
      }

       {
          name: GPIO_12_MUX_SEL
          desc: '''
              Pad signal port multiplex selection for pad gpio_12. The programmed value defines which port
              is connected to the pad.
          '''
          swaccess: "rw"
          hwaccess: "hro"
          resval: 0
          fields: [
              {
                  bits: "2:0"
                  enum: [
                      { value: "0", name: "register", desc: "Connects the Pad to the internal configuration register."}
                      { value: "1", name: "port_i2c_0_scl0", desc: "Connect port scl0 from port group i2c_0 to this pad." }
                      { value: "2", name: "port_i2c_0_sda0", desc: "Connect port sda0 from port group i2c_0 to this pad." }
                      { value: "3", name: "port_spi_csn", desc: "Connect port csn from port group spi to this pad." }
                      { value: "4", name: "port_spi_miso", desc: "Connect port miso from port group spi to this pad." }
                      { value: "5", name: "port_spi_mosi", desc: "Connect port mosi from port group spi to this pad." }
                      { value: "6", name: "port_spi_sck", desc: "Connect port sck from port group spi to this pad." }
                  ]
              }
          ]
      }

      {
          name: GPIO_13_CFG
          desc: '''
            Pad signal configuration.
          '''
          swaccess: "rw"
          fields: [
            {
                bits: "0"
                name: chip2pad
                desc: '''
                     The signal that connects to the pads TX driver
                '''
                swaccess: "rw"
                hwaccess: "hro"
                resval: "1"
            },
            {
                bits: "1"
                name: output_en
                desc: '''
                     Enables the output driver of the pad
                '''
                swaccess: "rw"
                hwaccess: "hro"
                resval: "0"
            },
            {
                bits: "2"
                name: rx_en
                desc: '''
                     Input buffer enable
                '''
                swaccess: "rw"
                hwaccess: "hro"
                resval: "0"
            },
          ]
      }

       {
          name: GPIO_13_MUX_SEL
          desc: '''
              Pad signal port multiplex selection for pad gpio_13. The programmed value defines which port
              is connected to the pad.
          '''
          swaccess: "rw"
          hwaccess: "hro"
          resval: 0
          fields: [
              {
                  bits: "2:0"
                  enum: [
                      { value: "0", name: "register", desc: "Connects the Pad to the internal configuration register."}
                      { value: "1", name: "port_i2c_0_scl0", desc: "Connect port scl0 from port group i2c_0 to this pad." }
                      { value: "2", name: "port_i2c_0_sda0", desc: "Connect port sda0 from port group i2c_0 to this pad." }
                      { value: "3", name: "port_spi_csn", desc: "Connect port csn from port group spi to this pad." }
                      { value: "4", name: "port_spi_miso", desc: "Connect port miso from port group spi to this pad." }
                      { value: "5", name: "port_spi_mosi", desc: "Connect port mosi from port group spi to this pad." }
                      { value: "6", name: "port_spi_sck", desc: "Connect port sck from port group spi to this pad." }
                  ]
              }
          ]
      }

      {
          name: GPIO_14_CFG
          desc: '''
            Pad signal configuration.
          '''
          swaccess: "rw"
          fields: [
            {
                bits: "0"
                name: chip2pad
                desc: '''
                     The signal that connects to the pads TX driver
                '''
                swaccess: "rw"
                hwaccess: "hro"
                resval: "1"
            },
            {
                bits: "1"
                name: output_en
                desc: '''
                     Enables the output driver of the pad
                '''
                swaccess: "rw"
                hwaccess: "hro"
                resval: "0"
            },
            {
                bits: "2"
                name: rx_en
                desc: '''
                     Input buffer enable
                '''
                swaccess: "rw"
                hwaccess: "hro"
                resval: "0"
            },
          ]
      }

       {
          name: GPIO_14_MUX_SEL
          desc: '''
              Pad signal port multiplex selection for pad gpio_14. The programmed value defines which port
              is connected to the pad.
          '''
          swaccess: "rw"
          hwaccess: "hro"
          resval: 0
          fields: [
              {
                  bits: "2:0"
                  enum: [
                      { value: "0", name: "register", desc: "Connects the Pad to the internal configuration register."}
                      { value: "1", name: "port_i2c_0_scl0", desc: "Connect port scl0 from port group i2c_0 to this pad." }
                      { value: "2", name: "port_i2c_0_sda0", desc: "Connect port sda0 from port group i2c_0 to this pad." }
                      { value: "3", name: "port_spi_csn", desc: "Connect port csn from port group spi to this pad." }
                      { value: "4", name: "port_spi_miso", desc: "Connect port miso from port group spi to this pad." }
                      { value: "5", name: "port_spi_mosi", desc: "Connect port mosi from port group spi to this pad." }
                      { value: "6", name: "port_spi_sck", desc: "Connect port sck from port group spi to this pad." }
                  ]
              }
          ]
      }

      {
          name: GPIO_15_CFG
          desc: '''
            Pad signal configuration.
          '''
          swaccess: "rw"
          fields: [
            {
                bits: "0"
                name: chip2pad
                desc: '''
                     The signal that connects to the pads TX driver
                '''
                swaccess: "rw"
                hwaccess: "hro"
                resval: "1"
            },
            {
                bits: "1"
                name: output_en
                desc: '''
                     Enables the output driver of the pad
                '''
                swaccess: "rw"
                hwaccess: "hro"
                resval: "0"
            },
            {
                bits: "2"
                name: rx_en
                desc: '''
                     Input buffer enable
                '''
                swaccess: "rw"
                hwaccess: "hro"
                resval: "0"
            },
          ]
      }

       {
          name: GPIO_15_MUX_SEL
          desc: '''
              Pad signal port multiplex selection for pad gpio_15. The programmed value defines which port
              is connected to the pad.
          '''
          swaccess: "rw"
          hwaccess: "hro"
          resval: 0
          fields: [
              {
                  bits: "2:0"
                  enum: [
                      { value: "0", name: "register", desc: "Connects the Pad to the internal configuration register."}
                      { value: "1", name: "port_i2c_0_scl0", desc: "Connect port scl0 from port group i2c_0 to this pad." }
                      { value: "2", name: "port_i2c_0_sda0", desc: "Connect port sda0 from port group i2c_0 to this pad." }
                      { value: "3", name: "port_spi_csn", desc: "Connect port csn from port group spi to this pad." }
                      { value: "4", name: "port_spi_miso", desc: "Connect port miso from port group spi to this pad." }
                      { value: "5", name: "port_spi_mosi", desc: "Connect port mosi from port group spi to this pad." }
                      { value: "6", name: "port_spi_sck", desc: "Connect port sck from port group spi to this pad." }
                  ]
              }
          ]
      }

      {
          name: GPIO_16_CFG
          desc: '''
            Pad signal configuration.
          '''
          swaccess: "rw"
          fields: [
            {
                bits: "0"
                name: chip2pad
                desc: '''
                     The signal that connects to the pads TX driver
                '''
                swaccess: "rw"
                hwaccess: "hro"
                resval: "1"
            },
            {
                bits: "1"
                name: output_en
                desc: '''
                     Enables the output driver of the pad
                '''
                swaccess: "rw"
                hwaccess: "hro"
                resval: "0"
            },
            {
                bits: "2"
                name: rx_en
                desc: '''
                     Input buffer enable
                '''
                swaccess: "rw"
                hwaccess: "hro"
                resval: "0"
            },
          ]
      }

       {
          name: GPIO_16_MUX_SEL
          desc: '''
              Pad signal port multiplex selection for pad gpio_16. The programmed value defines which port
              is connected to the pad.
          '''
          swaccess: "rw"
          hwaccess: "hro"
          resval: 0
          fields: [
              {
                  bits: "2:0"
                  enum: [
                      { value: "0", name: "register", desc: "Connects the Pad to the internal configuration register."}
                      { value: "1", name: "port_i2c_0_scl0", desc: "Connect port scl0 from port group i2c_0 to this pad." }
                      { value: "2", name: "port_i2c_0_sda0", desc: "Connect port sda0 from port group i2c_0 to this pad." }
                      { value: "3", name: "port_spi_csn", desc: "Connect port csn from port group spi to this pad." }
                      { value: "4", name: "port_spi_miso", desc: "Connect port miso from port group spi to this pad." }
                      { value: "5", name: "port_spi_mosi", desc: "Connect port mosi from port group spi to this pad." }
                      { value: "6", name: "port_spi_sck", desc: "Connect port sck from port group spi to this pad." }
                  ]
              }
          ]
      }

      {
          name: GPIO_17_CFG
          desc: '''
            Pad signal configuration.
          '''
          swaccess: "rw"
          fields: [
            {
                bits: "0"
                name: chip2pad
                desc: '''
                     The signal that connects to the pads TX driver
                '''
                swaccess: "rw"
                hwaccess: "hro"
                resval: "1"
            },
            {
                bits: "1"
                name: output_en
                desc: '''
                     Enables the output driver of the pad
                '''
                swaccess: "rw"
                hwaccess: "hro"
                resval: "0"
            },
            {
                bits: "2"
                name: rx_en
                desc: '''
                     Input buffer enable
                '''
                swaccess: "rw"
                hwaccess: "hro"
                resval: "0"
            },
          ]
      }

       {
          name: GPIO_17_MUX_SEL
          desc: '''
              Pad signal port multiplex selection for pad gpio_17. The programmed value defines which port
              is connected to the pad.
          '''
          swaccess: "rw"
          hwaccess: "hro"
          resval: 0
          fields: [
              {
                  bits: "2:0"
                  enum: [
                      { value: "0", name: "register", desc: "Connects the Pad to the internal configuration register."}
                      { value: "1", name: "port_i2c_0_scl0", desc: "Connect port scl0 from port group i2c_0 to this pad." }
                      { value: "2", name: "port_i2c_0_sda0", desc: "Connect port sda0 from port group i2c_0 to this pad." }
                      { value: "3", name: "port_spi_csn", desc: "Connect port csn from port group spi to this pad." }
                      { value: "4", name: "port_spi_miso", desc: "Connect port miso from port group spi to this pad." }
                      { value: "5", name: "port_spi_mosi", desc: "Connect port mosi from port group spi to this pad." }
                      { value: "6", name: "port_spi_sck", desc: "Connect port sck from port group spi to this pad." }
                  ]
              }
          ]
      }

      {
          name: GPIO_18_CFG
          desc: '''
            Pad signal configuration.
          '''
          swaccess: "rw"
          fields: [
            {
                bits: "0"
                name: chip2pad
                desc: '''
                     The signal that connects to the pads TX driver
                '''
                swaccess: "rw"
                hwaccess: "hro"
                resval: "1"
            },
            {
                bits: "1"
                name: output_en
                desc: '''
                     Enables the output driver of the pad
                '''
                swaccess: "rw"
                hwaccess: "hro"
                resval: "0"
            },
            {
                bits: "2"
                name: rx_en
                desc: '''
                     Input buffer enable
                '''
                swaccess: "rw"
                hwaccess: "hro"
                resval: "0"
            },
          ]
      }

       {
          name: GPIO_18_MUX_SEL
          desc: '''
              Pad signal port multiplex selection for pad gpio_18. The programmed value defines which port
              is connected to the pad.
          '''
          swaccess: "rw"
          hwaccess: "hro"
          resval: 0
          fields: [
              {
                  bits: "2:0"
                  enum: [
                      { value: "0", name: "register", desc: "Connects the Pad to the internal configuration register."}
                      { value: "1", name: "port_i2c_0_scl0", desc: "Connect port scl0 from port group i2c_0 to this pad." }
                      { value: "2", name: "port_i2c_0_sda0", desc: "Connect port sda0 from port group i2c_0 to this pad." }
                      { value: "3", name: "port_spi_csn", desc: "Connect port csn from port group spi to this pad." }
                      { value: "4", name: "port_spi_miso", desc: "Connect port miso from port group spi to this pad." }
                      { value: "5", name: "port_spi_mosi", desc: "Connect port mosi from port group spi to this pad." }
                      { value: "6", name: "port_spi_sck", desc: "Connect port sck from port group spi to this pad." }
                  ]
              }
          ]
      }

      {
          name: GPIO_19_CFG
          desc: '''
            Pad signal configuration.
          '''
          swaccess: "rw"
          fields: [
            {
                bits: "0"
                name: chip2pad
                desc: '''
                     The signal that connects to the pads TX driver
                '''
                swaccess: "rw"
                hwaccess: "hro"
                resval: "1"
            },
            {
                bits: "1"
                name: output_en
                desc: '''
                     Enables the output driver of the pad
                '''
                swaccess: "rw"
                hwaccess: "hro"
                resval: "0"
            },
            {
                bits: "2"
                name: rx_en
                desc: '''
                     Input buffer enable
                '''
                swaccess: "rw"
                hwaccess: "hro"
                resval: "0"
            },
          ]
      }

       {
          name: GPIO_19_MUX_SEL
          desc: '''
              Pad signal port multiplex selection for pad gpio_19. The programmed value defines which port
              is connected to the pad.
          '''
          swaccess: "rw"
          hwaccess: "hro"
          resval: 0
          fields: [
              {
                  bits: "2:0"
                  enum: [
                      { value: "0", name: "register", desc: "Connects the Pad to the internal configuration register."}
                      { value: "1", name: "port_i2c_0_scl0", desc: "Connect port scl0 from port group i2c_0 to this pad." }
                      { value: "2", name: "port_i2c_0_sda0", desc: "Connect port sda0 from port group i2c_0 to this pad." }
                      { value: "3", name: "port_spi_csn", desc: "Connect port csn from port group spi to this pad." }
                      { value: "4", name: "port_spi_miso", desc: "Connect port miso from port group spi to this pad." }
                      { value: "5", name: "port_spi_mosi", desc: "Connect port mosi from port group spi to this pad." }
                      { value: "6", name: "port_spi_sck", desc: "Connect port sck from port group spi to this pad." }
                  ]
              }
          ]
      }

      {
          name: GPIO_20_CFG
          desc: '''
            Pad signal configuration.
          '''
          swaccess: "rw"
          fields: [
            {
                bits: "0"
                name: chip2pad
                desc: '''
                     The signal that connects to the pads TX driver
                '''
                swaccess: "rw"
                hwaccess: "hro"
                resval: "1"
            },
            {
                bits: "1"
                name: output_en
                desc: '''
                     Enables the output driver of the pad
                '''
                swaccess: "rw"
                hwaccess: "hro"
                resval: "0"
            },
            {
                bits: "2"
                name: rx_en
                desc: '''
                     Input buffer enable
                '''
                swaccess: "rw"
                hwaccess: "hro"
                resval: "0"
            },
          ]
      }

       {
          name: GPIO_20_MUX_SEL
          desc: '''
              Pad signal port multiplex selection for pad gpio_20. The programmed value defines which port
              is connected to the pad.
          '''
          swaccess: "rw"
          hwaccess: "hro"
          resval: 0
          fields: [
              {
                  bits: "2:0"
                  enum: [
                      { value: "0", name: "register", desc: "Connects the Pad to the internal configuration register."}
                      { value: "1", name: "port_i2c_0_scl0", desc: "Connect port scl0 from port group i2c_0 to this pad." }
                      { value: "2", name: "port_i2c_0_sda0", desc: "Connect port sda0 from port group i2c_0 to this pad." }
                      { value: "3", name: "port_spi_csn", desc: "Connect port csn from port group spi to this pad." }
                      { value: "4", name: "port_spi_miso", desc: "Connect port miso from port group spi to this pad." }
                      { value: "5", name: "port_spi_mosi", desc: "Connect port mosi from port group spi to this pad." }
                      { value: "6", name: "port_spi_sck", desc: "Connect port sck from port group spi to this pad." }
                  ]
              }
          ]
      }

      {
          name: GPIO_21_CFG
          desc: '''
            Pad signal configuration.
          '''
          swaccess: "rw"
          fields: [
            {
                bits: "0"
                name: chip2pad
                desc: '''
                     The signal that connects to the pads TX driver
                '''
                swaccess: "rw"
                hwaccess: "hro"
                resval: "1"
            },
            {
                bits: "1"
                name: output_en
                desc: '''
                     Enables the output driver of the pad
                '''
                swaccess: "rw"
                hwaccess: "hro"
                resval: "0"
            },
            {
                bits: "2"
                name: rx_en
                desc: '''
                     Input buffer enable
                '''
                swaccess: "rw"
                hwaccess: "hro"
                resval: "0"
            },
          ]
      }

       {
          name: GPIO_21_MUX_SEL
          desc: '''
              Pad signal port multiplex selection for pad gpio_21. The programmed value defines which port
              is connected to the pad.
          '''
          swaccess: "rw"
          hwaccess: "hro"
          resval: 0
          fields: [
              {
                  bits: "2:0"
                  enum: [
                      { value: "0", name: "register", desc: "Connects the Pad to the internal configuration register."}
                      { value: "1", name: "port_i2c_0_scl0", desc: "Connect port scl0 from port group i2c_0 to this pad." }
                      { value: "2", name: "port_i2c_0_sda0", desc: "Connect port sda0 from port group i2c_0 to this pad." }
                      { value: "3", name: "port_spi_csn", desc: "Connect port csn from port group spi to this pad." }
                      { value: "4", name: "port_spi_miso", desc: "Connect port miso from port group spi to this pad." }
                      { value: "5", name: "port_spi_mosi", desc: "Connect port mosi from port group spi to this pad." }
                      { value: "6", name: "port_spi_sck", desc: "Connect port sck from port group spi to this pad." }
                  ]
              }
          ]
      }

      {
          name: GPIO_22_CFG
          desc: '''
            Pad signal configuration.
          '''
          swaccess: "rw"
          fields: [
            {
                bits: "0"
                name: chip2pad
                desc: '''
                     The signal that connects to the pads TX driver
                '''
                swaccess: "rw"
                hwaccess: "hro"
                resval: "1"
            },
            {
                bits: "1"
                name: output_en
                desc: '''
                     Enables the output driver of the pad
                '''
                swaccess: "rw"
                hwaccess: "hro"
                resval: "0"
            },
            {
                bits: "2"
                name: rx_en
                desc: '''
                     Input buffer enable
                '''
                swaccess: "rw"
                hwaccess: "hro"
                resval: "0"
            },
          ]
      }

       {
          name: GPIO_22_MUX_SEL
          desc: '''
              Pad signal port multiplex selection for pad gpio_22. The programmed value defines which port
              is connected to the pad.
          '''
          swaccess: "rw"
          hwaccess: "hro"
          resval: 0
          fields: [
              {
                  bits: "2:0"
                  enum: [
                      { value: "0", name: "register", desc: "Connects the Pad to the internal configuration register."}
                      { value: "1", name: "port_i2c_0_scl0", desc: "Connect port scl0 from port group i2c_0 to this pad." }
                      { value: "2", name: "port_i2c_0_sda0", desc: "Connect port sda0 from port group i2c_0 to this pad." }
                      { value: "3", name: "port_spi_csn", desc: "Connect port csn from port group spi to this pad." }
                      { value: "4", name: "port_spi_miso", desc: "Connect port miso from port group spi to this pad." }
                      { value: "5", name: "port_spi_mosi", desc: "Connect port mosi from port group spi to this pad." }
                      { value: "6", name: "port_spi_sck", desc: "Connect port sck from port group spi to this pad." }
                  ]
              }
          ]
      }

      {
          name: GPIO_23_CFG
          desc: '''
            Pad signal configuration.
          '''
          swaccess: "rw"
          fields: [
            {
                bits: "0"
                name: chip2pad
                desc: '''
                     The signal that connects to the pads TX driver
                '''
                swaccess: "rw"
                hwaccess: "hro"
                resval: "1"
            },
            {
                bits: "1"
                name: output_en
                desc: '''
                     Enables the output driver of the pad
                '''
                swaccess: "rw"
                hwaccess: "hro"
                resval: "0"
            },
            {
                bits: "2"
                name: rx_en
                desc: '''
                     Input buffer enable
                '''
                swaccess: "rw"
                hwaccess: "hro"
                resval: "0"
            },
          ]
      }

       {
          name: GPIO_23_MUX_SEL
          desc: '''
              Pad signal port multiplex selection for pad gpio_23. The programmed value defines which port
              is connected to the pad.
          '''
          swaccess: "rw"
          hwaccess: "hro"
          resval: 0
          fields: [
              {
                  bits: "2:0"
                  enum: [
                      { value: "0", name: "register", desc: "Connects the Pad to the internal configuration register."}
                      { value: "1", name: "port_i2c_0_scl0", desc: "Connect port scl0 from port group i2c_0 to this pad." }
                      { value: "2", name: "port_i2c_0_sda0", desc: "Connect port sda0 from port group i2c_0 to this pad." }
                      { value: "3", name: "port_spi_csn", desc: "Connect port csn from port group spi to this pad." }
                      { value: "4", name: "port_spi_miso", desc: "Connect port miso from port group spi to this pad." }
                      { value: "5", name: "port_spi_mosi", desc: "Connect port mosi from port group spi to this pad." }
                      { value: "6", name: "port_spi_sck", desc: "Connect port sck from port group spi to this pad." }
                  ]
              }
          ]
      }

      {
          name: GPIO_24_CFG
          desc: '''
            Pad signal configuration.
          '''
          swaccess: "rw"
          fields: [
            {
                bits: "0"
                name: chip2pad
                desc: '''
                     The signal that connects to the pads TX driver
                '''
                swaccess: "rw"
                hwaccess: "hro"
                resval: "1"
            },
            {
                bits: "1"
                name: output_en
                desc: '''
                     Enables the output driver of the pad
                '''
                swaccess: "rw"
                hwaccess: "hro"
                resval: "0"
            },
            {
                bits: "2"
                name: rx_en
                desc: '''
                     Input buffer enable
                '''
                swaccess: "rw"
                hwaccess: "hro"
                resval: "0"
            },
          ]
      }

       {
          name: GPIO_24_MUX_SEL
          desc: '''
              Pad signal port multiplex selection for pad gpio_24. The programmed value defines which port
              is connected to the pad.
          '''
          swaccess: "rw"
          hwaccess: "hro"
          resval: 0
          fields: [
              {
                  bits: "2:0"
                  enum: [
                      { value: "0", name: "register", desc: "Connects the Pad to the internal configuration register."}
                      { value: "1", name: "port_i2c_0_scl0", desc: "Connect port scl0 from port group i2c_0 to this pad." }
                      { value: "2", name: "port_i2c_0_sda0", desc: "Connect port sda0 from port group i2c_0 to this pad." }
                      { value: "3", name: "port_spi_csn", desc: "Connect port csn from port group spi to this pad." }
                      { value: "4", name: "port_spi_miso", desc: "Connect port miso from port group spi to this pad." }
                      { value: "5", name: "port_spi_mosi", desc: "Connect port mosi from port group spi to this pad." }
                      { value: "6", name: "port_spi_sck", desc: "Connect port sck from port group spi to this pad." }
                  ]
              }
          ]
      }

      {
          name: GPIO_25_CFG
          desc: '''
            Pad signal configuration.
          '''
          swaccess: "rw"
          fields: [
            {
                bits: "0"
                name: chip2pad
                desc: '''
                     The signal that connects to the pads TX driver
                '''
                swaccess: "rw"
                hwaccess: "hro"
                resval: "1"
            },
            {
                bits: "1"
                name: output_en
                desc: '''
                     Enables the output driver of the pad
                '''
                swaccess: "rw"
                hwaccess: "hro"
                resval: "0"
            },
            {
                bits: "2"
                name: rx_en
                desc: '''
                     Input buffer enable
                '''
                swaccess: "rw"
                hwaccess: "hro"
                resval: "0"
            },
          ]
      }

       {
          name: GPIO_25_MUX_SEL
          desc: '''
              Pad signal port multiplex selection for pad gpio_25. The programmed value defines which port
              is connected to the pad.
          '''
          swaccess: "rw"
          hwaccess: "hro"
          resval: 0
          fields: [
              {
                  bits: "2:0"
                  enum: [
                      { value: "0", name: "register", desc: "Connects the Pad to the internal configuration register."}
                      { value: "1", name: "port_i2c_0_scl0", desc: "Connect port scl0 from port group i2c_0 to this pad." }
                      { value: "2", name: "port_i2c_0_sda0", desc: "Connect port sda0 from port group i2c_0 to this pad." }
                      { value: "3", name: "port_spi_csn", desc: "Connect port csn from port group spi to this pad." }
                      { value: "4", name: "port_spi_miso", desc: "Connect port miso from port group spi to this pad." }
                      { value: "5", name: "port_spi_mosi", desc: "Connect port mosi from port group spi to this pad." }
                      { value: "6", name: "port_spi_sck", desc: "Connect port sck from port group spi to this pad." }
                  ]
              }
          ]
      }

      {
          name: GPIO_26_CFG
          desc: '''
            Pad signal configuration.
          '''
          swaccess: "rw"
          fields: [
            {
                bits: "0"
                name: chip2pad
                desc: '''
                     The signal that connects to the pads TX driver
                '''
                swaccess: "rw"
                hwaccess: "hro"
                resval: "1"
            },
            {
                bits: "1"
                name: output_en
                desc: '''
                     Enables the output driver of the pad
                '''
                swaccess: "rw"
                hwaccess: "hro"
                resval: "0"
            },
            {
                bits: "2"
                name: rx_en
                desc: '''
                     Input buffer enable
                '''
                swaccess: "rw"
                hwaccess: "hro"
                resval: "0"
            },
          ]
      }

       {
          name: GPIO_26_MUX_SEL
          desc: '''
              Pad signal port multiplex selection for pad gpio_26. The programmed value defines which port
              is connected to the pad.
          '''
          swaccess: "rw"
          hwaccess: "hro"
          resval: 0
          fields: [
              {
                  bits: "2:0"
                  enum: [
                      { value: "0", name: "register", desc: "Connects the Pad to the internal configuration register."}
                      { value: "1", name: "port_i2c_0_scl0", desc: "Connect port scl0 from port group i2c_0 to this pad." }
                      { value: "2", name: "port_i2c_0_sda0", desc: "Connect port sda0 from port group i2c_0 to this pad." }
                      { value: "3", name: "port_spi_csn", desc: "Connect port csn from port group spi to this pad." }
                      { value: "4", name: "port_spi_miso", desc: "Connect port miso from port group spi to this pad." }
                      { value: "5", name: "port_spi_mosi", desc: "Connect port mosi from port group spi to this pad." }
                      { value: "6", name: "port_spi_sck", desc: "Connect port sck from port group spi to this pad." }
                  ]
              }
          ]
      }

      {
          name: GPIO_27_CFG
          desc: '''
            Pad signal configuration.
          '''
          swaccess: "rw"
          fields: [
            {
                bits: "0"
                name: chip2pad
                desc: '''
                     The signal that connects to the pads TX driver
                '''
                swaccess: "rw"
                hwaccess: "hro"
                resval: "1"
            },
            {
                bits: "1"
                name: output_en
                desc: '''
                     Enables the output driver of the pad
                '''
                swaccess: "rw"
                hwaccess: "hro"
                resval: "0"
            },
            {
                bits: "2"
                name: rx_en
                desc: '''
                     Input buffer enable
                '''
                swaccess: "rw"
                hwaccess: "hro"
                resval: "0"
            },
          ]
      }

       {
          name: GPIO_27_MUX_SEL
          desc: '''
              Pad signal port multiplex selection for pad gpio_27. The programmed value defines which port
              is connected to the pad.
          '''
          swaccess: "rw"
          hwaccess: "hro"
          resval: 0
          fields: [
              {
                  bits: "2:0"
                  enum: [
                      { value: "0", name: "register", desc: "Connects the Pad to the internal configuration register."}
                      { value: "1", name: "port_i2c_0_scl0", desc: "Connect port scl0 from port group i2c_0 to this pad." }
                      { value: "2", name: "port_i2c_0_sda0", desc: "Connect port sda0 from port group i2c_0 to this pad." }
                      { value: "3", name: "port_spi_csn", desc: "Connect port csn from port group spi to this pad." }
                      { value: "4", name: "port_spi_miso", desc: "Connect port miso from port group spi to this pad." }
                      { value: "5", name: "port_spi_mosi", desc: "Connect port mosi from port group spi to this pad." }
                      { value: "6", name: "port_spi_sck", desc: "Connect port sck from port group spi to this pad." }
                  ]
              }
          ]
      }

      {
          name: GPIO_28_CFG
          desc: '''
            Pad signal configuration.
          '''
          swaccess: "rw"
          fields: [
            {
                bits: "0"
                name: chip2pad
                desc: '''
                     The signal that connects to the pads TX driver
                '''
                swaccess: "rw"
                hwaccess: "hro"
                resval: "1"
            },
            {
                bits: "1"
                name: output_en
                desc: '''
                     Enables the output driver of the pad
                '''
                swaccess: "rw"
                hwaccess: "hro"
                resval: "0"
            },
            {
                bits: "2"
                name: rx_en
                desc: '''
                     Input buffer enable
                '''
                swaccess: "rw"
                hwaccess: "hro"
                resval: "0"
            },
          ]
      }

       {
          name: GPIO_28_MUX_SEL
          desc: '''
              Pad signal port multiplex selection for pad gpio_28. The programmed value defines which port
              is connected to the pad.
          '''
          swaccess: "rw"
          hwaccess: "hro"
          resval: 0
          fields: [
              {
                  bits: "2:0"
                  enum: [
                      { value: "0", name: "register", desc: "Connects the Pad to the internal configuration register."}
                      { value: "1", name: "port_i2c_0_scl0", desc: "Connect port scl0 from port group i2c_0 to this pad." }
                      { value: "2", name: "port_i2c_0_sda0", desc: "Connect port sda0 from port group i2c_0 to this pad." }
                      { value: "3", name: "port_spi_csn", desc: "Connect port csn from port group spi to this pad." }
                      { value: "4", name: "port_spi_miso", desc: "Connect port miso from port group spi to this pad." }
                      { value: "5", name: "port_spi_mosi", desc: "Connect port mosi from port group spi to this pad." }
                      { value: "6", name: "port_spi_sck", desc: "Connect port sck from port group spi to this pad." }
                  ]
              }
          ]
      }

      {
          name: GPIO_29_CFG
          desc: '''
            Pad signal configuration.
          '''
          swaccess: "rw"
          fields: [
            {
                bits: "0"
                name: chip2pad
                desc: '''
                     The signal that connects to the pads TX driver
                '''
                swaccess: "rw"
                hwaccess: "hro"
                resval: "1"
            },
            {
                bits: "1"
                name: output_en
                desc: '''
                     Enables the output driver of the pad
                '''
                swaccess: "rw"
                hwaccess: "hro"
                resval: "0"
            },
            {
                bits: "2"
                name: rx_en
                desc: '''
                     Input buffer enable
                '''
                swaccess: "rw"
                hwaccess: "hro"
                resval: "0"
            },
          ]
      }

       {
          name: GPIO_29_MUX_SEL
          desc: '''
              Pad signal port multiplex selection for pad gpio_29. The programmed value defines which port
              is connected to the pad.
          '''
          swaccess: "rw"
          hwaccess: "hro"
          resval: 0
          fields: [
              {
                  bits: "2:0"
                  enum: [
                      { value: "0", name: "register", desc: "Connects the Pad to the internal configuration register."}
                      { value: "1", name: "port_i2c_0_scl0", desc: "Connect port scl0 from port group i2c_0 to this pad." }
                      { value: "2", name: "port_i2c_0_sda0", desc: "Connect port sda0 from port group i2c_0 to this pad." }
                      { value: "3", name: "port_spi_csn", desc: "Connect port csn from port group spi to this pad." }
                      { value: "4", name: "port_spi_miso", desc: "Connect port miso from port group spi to this pad." }
                      { value: "5", name: "port_spi_mosi", desc: "Connect port mosi from port group spi to this pad." }
                      { value: "6", name: "port_spi_sck", desc: "Connect port sck from port group spi to this pad." }
                  ]
              }
          ]
      }

      {
          name: GPIO_30_CFG
          desc: '''
            Pad signal configuration.
          '''
          swaccess: "rw"
          fields: [
            {
                bits: "0"
                name: chip2pad
                desc: '''
                     The signal that connects to the pads TX driver
                '''
                swaccess: "rw"
                hwaccess: "hro"
                resval: "1"
            },
            {
                bits: "1"
                name: output_en
                desc: '''
                     Enables the output driver of the pad
                '''
                swaccess: "rw"
                hwaccess: "hro"
                resval: "0"
            },
            {
                bits: "2"
                name: rx_en
                desc: '''
                     Input buffer enable
                '''
                swaccess: "rw"
                hwaccess: "hro"
                resval: "0"
            },
          ]
      }

       {
          name: GPIO_30_MUX_SEL
          desc: '''
              Pad signal port multiplex selection for pad gpio_30. The programmed value defines which port
              is connected to the pad.
          '''
          swaccess: "rw"
          hwaccess: "hro"
          resval: 0
          fields: [
              {
                  bits: "2:0"
                  enum: [
                      { value: "0", name: "register", desc: "Connects the Pad to the internal configuration register."}
                      { value: "1", name: "port_i2c_0_scl0", desc: "Connect port scl0 from port group i2c_0 to this pad." }
                      { value: "2", name: "port_i2c_0_sda0", desc: "Connect port sda0 from port group i2c_0 to this pad." }
                      { value: "3", name: "port_spi_csn", desc: "Connect port csn from port group spi to this pad." }
                      { value: "4", name: "port_spi_miso", desc: "Connect port miso from port group spi to this pad." }
                      { value: "5", name: "port_spi_mosi", desc: "Connect port mosi from port group spi to this pad." }
                      { value: "6", name: "port_spi_sck", desc: "Connect port sck from port group spi to this pad." }
                  ]
              }
          ]
      }

      {
          name: GPIO_31_CFG
          desc: '''
            Pad signal configuration.
          '''
          swaccess: "rw"
          fields: [
            {
                bits: "0"
                name: chip2pad
                desc: '''
                     The signal that connects to the pads TX driver
                '''
                swaccess: "rw"
                hwaccess: "hro"
                resval: "1"
            },
            {
                bits: "1"
                name: output_en
                desc: '''
                     Enables the output driver of the pad
                '''
                swaccess: "rw"
                hwaccess: "hro"
                resval: "0"
            },
            {
                bits: "2"
                name: rx_en
                desc: '''
                     Input buffer enable
                '''
                swaccess: "rw"
                hwaccess: "hro"
                resval: "0"
            },
          ]
      }

       {
          name: GPIO_31_MUX_SEL
          desc: '''
              Pad signal port multiplex selection for pad gpio_31. The programmed value defines which port
              is connected to the pad.
          '''
          swaccess: "rw"
          hwaccess: "hro"
          resval: 0
          fields: [
              {
                  bits: "5:0"
                  enum: [
                      { value: "0", name: "register", desc: "Connects the Pad to the internal configuration register."}
                      { value: "1", name: "port_GPIOA0_gpio0", desc: "Connect port gpio0 from port group GPIOA0 to this pad." }
                      { value: "2", name: "port_GPIOA1_gpio0", desc: "Connect port gpio0 from port group GPIOA1 to this pad." }
                      { value: "3", name: "port_GPIOA2_gpio0", desc: "Connect port gpio0 from port group GPIOA2 to this pad." }
                      { value: "4", name: "port_GPIOA3_gpio0", desc: "Connect port gpio0 from port group GPIOA3 to this pad." }
                      { value: "5", name: "port_GPIOA4_gpio0", desc: "Connect port gpio0 from port group GPIOA4 to this pad." }
                      { value: "6", name: "port_GPIOA5_gpio0", desc: "Connect port gpio0 from port group GPIOA5 to this pad." }
                      { value: "7", name: "port_GPIOA6_gpio0", desc: "Connect port gpio0 from port group GPIOA6 to this pad." }
                      { value: "8", name: "port_GPIOA7_gpio0", desc: "Connect port gpio0 from port group GPIOA7 to this pad." }
                      { value: "9", name: "port_GPIOA8_gpio0", desc: "Connect port gpio0 from port group GPIOA8 to this pad." }
                      { value: "10", name: "port_GPIOA9_gpio0", desc: "Connect port gpio0 from port group GPIOA9 to this pad." }
                      { value: "11", name: "port_GPIOA10_gpio0", desc: "Connect port gpio0 from port group GPIOA10 to this pad." }
                      { value: "12", name: "port_GPIOA11_gpio0", desc: "Connect port gpio0 from port group GPIOA11 to this pad." }
                      { value: "13", name: "port_GPIOA12_gpio0", desc: "Connect port gpio0 from port group GPIOA12 to this pad." }
                      { value: "14", name: "port_GPIOA13_gpio0", desc: "Connect port gpio0 from port group GPIOA13 to this pad." }
                      { value: "15", name: "port_GPIOA14_gpio0", desc: "Connect port gpio0 from port group GPIOA14 to this pad." }
                      { value: "16", name: "port_GPIOA15_gpio0", desc: "Connect port gpio0 from port group GPIOA15 to this pad." }
                      { value: "17", name: "port_GPIOA16_gpio0", desc: "Connect port gpio0 from port group GPIOA16 to this pad." }
                      { value: "18", name: "port_GPIOA17_gpio0", desc: "Connect port gpio0 from port group GPIOA17 to this pad." }
                      { value: "19", name: "port_GPIOA18_gpio0", desc: "Connect port gpio0 from port group GPIOA18 to this pad." }
                      { value: "20", name: "port_GPIOA19_gpio0", desc: "Connect port gpio0 from port group GPIOA19 to this pad." }
                      { value: "21", name: "port_GPIOA20_gpio0", desc: "Connect port gpio0 from port group GPIOA20 to this pad." }
                      { value: "22", name: "port_GPIOA21_gpio0", desc: "Connect port gpio0 from port group GPIOA21 to this pad." }
                      { value: "23", name: "port_GPIOA22_gpio0", desc: "Connect port gpio0 from port group GPIOA22 to this pad." }
                      { value: "24", name: "port_GPIOA23_gpio0", desc: "Connect port gpio0 from port group GPIOA23 to this pad." }
                      { value: "25", name: "port_GPIOA24_gpio0", desc: "Connect port gpio0 from port group GPIOA24 to this pad." }
                      { value: "26", name: "port_GPIOA25_gpio0", desc: "Connect port gpio0 from port group GPIOA25 to this pad." }
                      { value: "27", name: "port_GPIOA26_gpio0", desc: "Connect port gpio0 from port group GPIOA26 to this pad." }
                      { value: "28", name: "port_GPIOA27_gpio0", desc: "Connect port gpio0 from port group GPIOA27 to this pad." }
                      { value: "29", name: "port_GPIOA28_gpio0", desc: "Connect port gpio0 from port group GPIOA28 to this pad." }
                      { value: "30", name: "port_GPIOA29_gpio0", desc: "Connect port gpio0 from port group GPIOA29 to this pad." }
                      { value: "31", name: "port_GPIOA30_gpio0", desc: "Connect port gpio0 from port group GPIOA30 to this pad." }
                      { value: "32", name: "port_GPIOA31_gpio0", desc: "Connect port gpio0 from port group GPIOA31 to this pad." }
                      { value: "33", name: "port_i2c_0_scl0", desc: "Connect port scl0 from port group i2c_0 to this pad." }
                      { value: "34", name: "port_i2c_0_sda0", desc: "Connect port sda0 from port group i2c_0 to this pad." }
                      { value: "35", name: "port_spi_csn", desc: "Connect port csn from port group spi to this pad." }
                      { value: "36", name: "port_spi_miso", desc: "Connect port miso from port group spi to this pad." }
                      { value: "37", name: "port_spi_mosi", desc: "Connect port mosi from port group spi to this pad." }
                      { value: "38", name: "port_spi_sck", desc: "Connect port sck from port group spi to this pad." }
                  ]
              }
          ]
      }

    ]
}
