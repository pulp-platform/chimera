
{
    # File auto-generated by Padrick unknown
    name: "chimera_padframe_aon_gpioa_config"
    clock_primary: "clk_i"
    reset_primary: "rst_ni"
    bus_interfaces: [
        { protocol: "reg_iface", direction: "device"}
    ]
    regwidth: 32,
    registers: [
        {skipto: "0x4"},
        {
            name: INFO
            desc: "Read-only IP Information register"
            swaccess: "ro"
            hwaccess: "hro"
            fields: [
              {
                bits: "15:0"
                name: HW_VERSION
                desc: "Hardware version ID."
                resval: 2
              },
              {
                  bits:"31:16"
                  name: PADCOUNT
                  desc: "The number of muxable pads in this IP."
                  resval: "32"
              }
            ]
        }
      {
          name: GPIO_0_CFG
          desc: '''
            Pad signal configuration.
          '''
          swaccess: "rw"
          fields: [
            {
                bits: "0"
                name: chip2pad
                desc: '''
                     Signal to connect internal Chip to the TX driver of the Pad
                '''
                swaccess: "rw"
                hwaccess: "hro"
                resval: "0"
            },
            {
                bits: "2:1"
                name: drv
                desc: '''
                     Driving Strength selector
                '''
                swaccess: "rw"
                hwaccess: "hro"
                resval: "3"
            },
            {
                bits: "3"
                name: pde
                desc: '''
                     Pull-Down resistor Enable
                '''
                swaccess: "rw"
                hwaccess: "hro"
                resval: "0"
            },
            {
                bits: "4"
                name: pue
                desc: '''
                     Pull-Up resistor Enable
                '''
                swaccess: "rw"
                hwaccess: "hro"
                resval: "0"
            },
            {
                bits: "5"
                name: rxe
                desc: '''
                     Active high RX enable
                '''
                swaccess: "rw"
                hwaccess: "hro"
                resval: "0"
            },
            {
                bits: "6"
                name: slw
                desc: '''
                     
                '''
                swaccess: "rw"
                hwaccess: "hro"
                resval: "0"
            },
            {
                bits: "7"
                name: smt
                desc: '''
                     Active High schmidt trigger Enable
                '''
                swaccess: "rw"
                hwaccess: "hro"
                resval: "0"
            },
            {
                bits: "8"
                name: trie
                desc: '''
                     Active high tri-state enable: trie = 1 -> buffer is in tri-state mode, i.e. Hi-Z. To Transmit trie = 0
                '''
                swaccess: "rw"
                hwaccess: "hro"
                resval: "1"
            },
          ]
      }

       {
          name: GPIO_0_MUX_SEL
          desc: '''
              Pad signal port multiplex selection for pad gpio_0. The programmed value defines which port
              is connected to the pad.
          '''
          swaccess: "rw"
          hwaccess: "hro"
          resval: 0
          fields: [
              {
                  bits: "3:0"
                  enum: [
                      { value: "0", name: "register", desc: "Connects the Pad to the internal configuration register."}
                      { value: "1", name: "port_i2c0_scl", desc: "Connect port scl from port group i2c0 to this pad." }
                      { value: "2", name: "port_i2c0_sda", desc: "Connect port sda from port group i2c0 to this pad." }
                      { value: "3", name: "port_qspi0_csb0", desc: "Connect port csb0 from port group qspi0 to this pad." }
                      { value: "4", name: "port_qspi0_csb1", desc: "Connect port csb1 from port group qspi0 to this pad." }
                      { value: "5", name: "port_qspi0_csb2", desc: "Connect port csb2 from port group qspi0 to this pad." }
                      { value: "6", name: "port_qspi0_sck", desc: "Connect port sck from port group qspi0 to this pad." }
                      { value: "7", name: "port_qspi0_sd0", desc: "Connect port sd0 from port group qspi0 to this pad." }
                      { value: "8", name: "port_qspi0_sd1", desc: "Connect port sd1 from port group qspi0 to this pad." }
                      { value: "9", name: "port_qspi0_sd2", desc: "Connect port sd2 from port group qspi0 to this pad." }
                      { value: "10", name: "port_qspi0_sd3", desc: "Connect port sd3 from port group qspi0 to this pad." }
                      { value: "11", name: "port_uart0_rx", desc: "Connect port rx from port group uart0 to this pad." }
                      { value: "12", name: "port_uart0_tx", desc: "Connect port tx from port group uart0 to this pad." }
                  ]
              }
          ]
      }

      {
          name: GPIO_1_CFG
          desc: '''
            Pad signal configuration.
          '''
          swaccess: "rw"
          fields: [
            {
                bits: "0"
                name: chip2pad
                desc: '''
                     Signal to connect internal Chip to the TX driver of the Pad
                '''
                swaccess: "rw"
                hwaccess: "hro"
                resval: "0"
            },
            {
                bits: "2:1"
                name: drv
                desc: '''
                     Driving Strength selector
                '''
                swaccess: "rw"
                hwaccess: "hro"
                resval: "3"
            },
            {
                bits: "3"
                name: pde
                desc: '''
                     Pull-Down resistor Enable
                '''
                swaccess: "rw"
                hwaccess: "hro"
                resval: "0"
            },
            {
                bits: "4"
                name: pue
                desc: '''
                     Pull-Up resistor Enable
                '''
                swaccess: "rw"
                hwaccess: "hro"
                resval: "0"
            },
            {
                bits: "5"
                name: rxe
                desc: '''
                     Active high RX enable
                '''
                swaccess: "rw"
                hwaccess: "hro"
                resval: "0"
            },
            {
                bits: "6"
                name: slw
                desc: '''
                     
                '''
                swaccess: "rw"
                hwaccess: "hro"
                resval: "0"
            },
            {
                bits: "7"
                name: smt
                desc: '''
                     Active High schmidt trigger Enable
                '''
                swaccess: "rw"
                hwaccess: "hro"
                resval: "0"
            },
            {
                bits: "8"
                name: trie
                desc: '''
                     Active high tri-state enable: trie = 1 -> buffer is in tri-state mode, i.e. Hi-Z. To Transmit trie = 0
                '''
                swaccess: "rw"
                hwaccess: "hro"
                resval: "1"
            },
          ]
      }

       {
          name: GPIO_1_MUX_SEL
          desc: '''
              Pad signal port multiplex selection for pad gpio_1. The programmed value defines which port
              is connected to the pad.
          '''
          swaccess: "rw"
          hwaccess: "hro"
          resval: 0
          fields: [
              {
                  bits: "3:0"
                  enum: [
                      { value: "0", name: "register", desc: "Connects the Pad to the internal configuration register."}
                      { value: "1", name: "port_i2c0_scl", desc: "Connect port scl from port group i2c0 to this pad." }
                      { value: "2", name: "port_i2c0_sda", desc: "Connect port sda from port group i2c0 to this pad." }
                      { value: "3", name: "port_qspi0_csb0", desc: "Connect port csb0 from port group qspi0 to this pad." }
                      { value: "4", name: "port_qspi0_csb1", desc: "Connect port csb1 from port group qspi0 to this pad." }
                      { value: "5", name: "port_qspi0_csb2", desc: "Connect port csb2 from port group qspi0 to this pad." }
                      { value: "6", name: "port_qspi0_sck", desc: "Connect port sck from port group qspi0 to this pad." }
                      { value: "7", name: "port_qspi0_sd0", desc: "Connect port sd0 from port group qspi0 to this pad." }
                      { value: "8", name: "port_qspi0_sd1", desc: "Connect port sd1 from port group qspi0 to this pad." }
                      { value: "9", name: "port_qspi0_sd2", desc: "Connect port sd2 from port group qspi0 to this pad." }
                      { value: "10", name: "port_qspi0_sd3", desc: "Connect port sd3 from port group qspi0 to this pad." }
                      { value: "11", name: "port_uart0_rx", desc: "Connect port rx from port group uart0 to this pad." }
                      { value: "12", name: "port_uart0_tx", desc: "Connect port tx from port group uart0 to this pad." }
                  ]
              }
          ]
      }

      {
          name: GPIO_2_CFG
          desc: '''
            Pad signal configuration.
          '''
          swaccess: "rw"
          fields: [
            {
                bits: "0"
                name: chip2pad
                desc: '''
                     Signal to connect internal Chip to the TX driver of the Pad
                '''
                swaccess: "rw"
                hwaccess: "hro"
                resval: "0"
            },
            {
                bits: "2:1"
                name: drv
                desc: '''
                     Driving Strength selector
                '''
                swaccess: "rw"
                hwaccess: "hro"
                resval: "3"
            },
            {
                bits: "3"
                name: pde
                desc: '''
                     Pull-Down resistor Enable
                '''
                swaccess: "rw"
                hwaccess: "hro"
                resval: "0"
            },
            {
                bits: "4"
                name: pue
                desc: '''
                     Pull-Up resistor Enable
                '''
                swaccess: "rw"
                hwaccess: "hro"
                resval: "0"
            },
            {
                bits: "5"
                name: rxe
                desc: '''
                     Active high RX enable
                '''
                swaccess: "rw"
                hwaccess: "hro"
                resval: "0"
            },
            {
                bits: "6"
                name: slw
                desc: '''
                     
                '''
                swaccess: "rw"
                hwaccess: "hro"
                resval: "0"
            },
            {
                bits: "7"
                name: smt
                desc: '''
                     Active High schmidt trigger Enable
                '''
                swaccess: "rw"
                hwaccess: "hro"
                resval: "0"
            },
            {
                bits: "8"
                name: trie
                desc: '''
                     Active high tri-state enable: trie = 1 -> buffer is in tri-state mode, i.e. Hi-Z. To Transmit trie = 0
                '''
                swaccess: "rw"
                hwaccess: "hro"
                resval: "1"
            },
          ]
      }

       {
          name: GPIO_2_MUX_SEL
          desc: '''
              Pad signal port multiplex selection for pad gpio_2. The programmed value defines which port
              is connected to the pad.
          '''
          swaccess: "rw"
          hwaccess: "hro"
          resval: 0
          fields: [
              {
                  bits: "3:0"
                  enum: [
                      { value: "0", name: "register", desc: "Connects the Pad to the internal configuration register."}
                      { value: "1", name: "port_i2c0_scl", desc: "Connect port scl from port group i2c0 to this pad." }
                      { value: "2", name: "port_i2c0_sda", desc: "Connect port sda from port group i2c0 to this pad." }
                      { value: "3", name: "port_qspi0_csb0", desc: "Connect port csb0 from port group qspi0 to this pad." }
                      { value: "4", name: "port_qspi0_csb1", desc: "Connect port csb1 from port group qspi0 to this pad." }
                      { value: "5", name: "port_qspi0_csb2", desc: "Connect port csb2 from port group qspi0 to this pad." }
                      { value: "6", name: "port_qspi0_sck", desc: "Connect port sck from port group qspi0 to this pad." }
                      { value: "7", name: "port_qspi0_sd0", desc: "Connect port sd0 from port group qspi0 to this pad." }
                      { value: "8", name: "port_qspi0_sd1", desc: "Connect port sd1 from port group qspi0 to this pad." }
                      { value: "9", name: "port_qspi0_sd2", desc: "Connect port sd2 from port group qspi0 to this pad." }
                      { value: "10", name: "port_qspi0_sd3", desc: "Connect port sd3 from port group qspi0 to this pad." }
                      { value: "11", name: "port_uart0_rx", desc: "Connect port rx from port group uart0 to this pad." }
                      { value: "12", name: "port_uart0_tx", desc: "Connect port tx from port group uart0 to this pad." }
                  ]
              }
          ]
      }

      {
          name: GPIO_3_CFG
          desc: '''
            Pad signal configuration.
          '''
          swaccess: "rw"
          fields: [
            {
                bits: "0"
                name: chip2pad
                desc: '''
                     Signal to connect internal Chip to the TX driver of the Pad
                '''
                swaccess: "rw"
                hwaccess: "hro"
                resval: "0"
            },
            {
                bits: "2:1"
                name: drv
                desc: '''
                     Driving Strength selector
                '''
                swaccess: "rw"
                hwaccess: "hro"
                resval: "3"
            },
            {
                bits: "3"
                name: pde
                desc: '''
                     Pull-Down resistor Enable
                '''
                swaccess: "rw"
                hwaccess: "hro"
                resval: "0"
            },
            {
                bits: "4"
                name: pue
                desc: '''
                     Pull-Up resistor Enable
                '''
                swaccess: "rw"
                hwaccess: "hro"
                resval: "0"
            },
            {
                bits: "5"
                name: rxe
                desc: '''
                     Active high RX enable
                '''
                swaccess: "rw"
                hwaccess: "hro"
                resval: "0"
            },
            {
                bits: "6"
                name: slw
                desc: '''
                     
                '''
                swaccess: "rw"
                hwaccess: "hro"
                resval: "0"
            },
            {
                bits: "7"
                name: smt
                desc: '''
                     Active High schmidt trigger Enable
                '''
                swaccess: "rw"
                hwaccess: "hro"
                resval: "0"
            },
            {
                bits: "8"
                name: trie
                desc: '''
                     Active high tri-state enable: trie = 1 -> buffer is in tri-state mode, i.e. Hi-Z. To Transmit trie = 0
                '''
                swaccess: "rw"
                hwaccess: "hro"
                resval: "1"
            },
          ]
      }

       {
          name: GPIO_3_MUX_SEL
          desc: '''
              Pad signal port multiplex selection for pad gpio_3. The programmed value defines which port
              is connected to the pad.
          '''
          swaccess: "rw"
          hwaccess: "hro"
          resval: 0
          fields: [
              {
                  bits: "3:0"
                  enum: [
                      { value: "0", name: "register", desc: "Connects the Pad to the internal configuration register."}
                      { value: "1", name: "port_i2c0_scl", desc: "Connect port scl from port group i2c0 to this pad." }
                      { value: "2", name: "port_i2c0_sda", desc: "Connect port sda from port group i2c0 to this pad." }
                      { value: "3", name: "port_qspi0_csb0", desc: "Connect port csb0 from port group qspi0 to this pad." }
                      { value: "4", name: "port_qspi0_csb1", desc: "Connect port csb1 from port group qspi0 to this pad." }
                      { value: "5", name: "port_qspi0_csb2", desc: "Connect port csb2 from port group qspi0 to this pad." }
                      { value: "6", name: "port_qspi0_sck", desc: "Connect port sck from port group qspi0 to this pad." }
                      { value: "7", name: "port_qspi0_sd0", desc: "Connect port sd0 from port group qspi0 to this pad." }
                      { value: "8", name: "port_qspi0_sd1", desc: "Connect port sd1 from port group qspi0 to this pad." }
                      { value: "9", name: "port_qspi0_sd2", desc: "Connect port sd2 from port group qspi0 to this pad." }
                      { value: "10", name: "port_qspi0_sd3", desc: "Connect port sd3 from port group qspi0 to this pad." }
                      { value: "11", name: "port_uart0_rx", desc: "Connect port rx from port group uart0 to this pad." }
                      { value: "12", name: "port_uart0_tx", desc: "Connect port tx from port group uart0 to this pad." }
                  ]
              }
          ]
      }

      {
          name: GPIO_4_CFG
          desc: '''
            Pad signal configuration.
          '''
          swaccess: "rw"
          fields: [
            {
                bits: "0"
                name: chip2pad
                desc: '''
                     Signal to connect internal Chip to the TX driver of the Pad
                '''
                swaccess: "rw"
                hwaccess: "hro"
                resval: "0"
            },
            {
                bits: "2:1"
                name: drv
                desc: '''
                     Driving Strength selector
                '''
                swaccess: "rw"
                hwaccess: "hro"
                resval: "3"
            },
            {
                bits: "3"
                name: pde
                desc: '''
                     Pull-Down resistor Enable
                '''
                swaccess: "rw"
                hwaccess: "hro"
                resval: "0"
            },
            {
                bits: "4"
                name: pue
                desc: '''
                     Pull-Up resistor Enable
                '''
                swaccess: "rw"
                hwaccess: "hro"
                resval: "0"
            },
            {
                bits: "5"
                name: rxe
                desc: '''
                     Active high RX enable
                '''
                swaccess: "rw"
                hwaccess: "hro"
                resval: "0"
            },
            {
                bits: "6"
                name: slw
                desc: '''
                     
                '''
                swaccess: "rw"
                hwaccess: "hro"
                resval: "0"
            },
            {
                bits: "7"
                name: smt
                desc: '''
                     Active High schmidt trigger Enable
                '''
                swaccess: "rw"
                hwaccess: "hro"
                resval: "0"
            },
            {
                bits: "8"
                name: trie
                desc: '''
                     Active high tri-state enable: trie = 1 -> buffer is in tri-state mode, i.e. Hi-Z. To Transmit trie = 0
                '''
                swaccess: "rw"
                hwaccess: "hro"
                resval: "1"
            },
          ]
      }

       {
          name: GPIO_4_MUX_SEL
          desc: '''
              Pad signal port multiplex selection for pad gpio_4. The programmed value defines which port
              is connected to the pad.
          '''
          swaccess: "rw"
          hwaccess: "hro"
          resval: 0
          fields: [
              {
                  bits: "3:0"
                  enum: [
                      { value: "0", name: "register", desc: "Connects the Pad to the internal configuration register."}
                      { value: "1", name: "port_i2c0_scl", desc: "Connect port scl from port group i2c0 to this pad." }
                      { value: "2", name: "port_i2c0_sda", desc: "Connect port sda from port group i2c0 to this pad." }
                      { value: "3", name: "port_qspi0_csb0", desc: "Connect port csb0 from port group qspi0 to this pad." }
                      { value: "4", name: "port_qspi0_csb1", desc: "Connect port csb1 from port group qspi0 to this pad." }
                      { value: "5", name: "port_qspi0_csb2", desc: "Connect port csb2 from port group qspi0 to this pad." }
                      { value: "6", name: "port_qspi0_sck", desc: "Connect port sck from port group qspi0 to this pad." }
                      { value: "7", name: "port_qspi0_sd0", desc: "Connect port sd0 from port group qspi0 to this pad." }
                      { value: "8", name: "port_qspi0_sd1", desc: "Connect port sd1 from port group qspi0 to this pad." }
                      { value: "9", name: "port_qspi0_sd2", desc: "Connect port sd2 from port group qspi0 to this pad." }
                      { value: "10", name: "port_qspi0_sd3", desc: "Connect port sd3 from port group qspi0 to this pad." }
                      { value: "11", name: "port_uart0_rx", desc: "Connect port rx from port group uart0 to this pad." }
                      { value: "12", name: "port_uart0_tx", desc: "Connect port tx from port group uart0 to this pad." }
                  ]
              }
          ]
      }

      {
          name: GPIO_5_CFG
          desc: '''
            Pad signal configuration.
          '''
          swaccess: "rw"
          fields: [
            {
                bits: "0"
                name: chip2pad
                desc: '''
                     Signal to connect internal Chip to the TX driver of the Pad
                '''
                swaccess: "rw"
                hwaccess: "hro"
                resval: "0"
            },
            {
                bits: "2:1"
                name: drv
                desc: '''
                     Driving Strength selector
                '''
                swaccess: "rw"
                hwaccess: "hro"
                resval: "3"
            },
            {
                bits: "3"
                name: pde
                desc: '''
                     Pull-Down resistor Enable
                '''
                swaccess: "rw"
                hwaccess: "hro"
                resval: "0"
            },
            {
                bits: "4"
                name: pue
                desc: '''
                     Pull-Up resistor Enable
                '''
                swaccess: "rw"
                hwaccess: "hro"
                resval: "0"
            },
            {
                bits: "5"
                name: rxe
                desc: '''
                     Active high RX enable
                '''
                swaccess: "rw"
                hwaccess: "hro"
                resval: "0"
            },
            {
                bits: "6"
                name: slw
                desc: '''
                     
                '''
                swaccess: "rw"
                hwaccess: "hro"
                resval: "0"
            },
            {
                bits: "7"
                name: smt
                desc: '''
                     Active High schmidt trigger Enable
                '''
                swaccess: "rw"
                hwaccess: "hro"
                resval: "0"
            },
            {
                bits: "8"
                name: trie
                desc: '''
                     Active high tri-state enable: trie = 1 -> buffer is in tri-state mode, i.e. Hi-Z. To Transmit trie = 0
                '''
                swaccess: "rw"
                hwaccess: "hro"
                resval: "1"
            },
          ]
      }

       {
          name: GPIO_5_MUX_SEL
          desc: '''
              Pad signal port multiplex selection for pad gpio_5. The programmed value defines which port
              is connected to the pad.
          '''
          swaccess: "rw"
          hwaccess: "hro"
          resval: 0
          fields: [
              {
                  bits: "3:0"
                  enum: [
                      { value: "0", name: "register", desc: "Connects the Pad to the internal configuration register."}
                      { value: "1", name: "port_i2c0_scl", desc: "Connect port scl from port group i2c0 to this pad." }
                      { value: "2", name: "port_i2c0_sda", desc: "Connect port sda from port group i2c0 to this pad." }
                      { value: "3", name: "port_qspi0_csb0", desc: "Connect port csb0 from port group qspi0 to this pad." }
                      { value: "4", name: "port_qspi0_csb1", desc: "Connect port csb1 from port group qspi0 to this pad." }
                      { value: "5", name: "port_qspi0_csb2", desc: "Connect port csb2 from port group qspi0 to this pad." }
                      { value: "6", name: "port_qspi0_sck", desc: "Connect port sck from port group qspi0 to this pad." }
                      { value: "7", name: "port_qspi0_sd0", desc: "Connect port sd0 from port group qspi0 to this pad." }
                      { value: "8", name: "port_qspi0_sd1", desc: "Connect port sd1 from port group qspi0 to this pad." }
                      { value: "9", name: "port_qspi0_sd2", desc: "Connect port sd2 from port group qspi0 to this pad." }
                      { value: "10", name: "port_qspi0_sd3", desc: "Connect port sd3 from port group qspi0 to this pad." }
                      { value: "11", name: "port_uart0_rx", desc: "Connect port rx from port group uart0 to this pad." }
                      { value: "12", name: "port_uart0_tx", desc: "Connect port tx from port group uart0 to this pad." }
                  ]
              }
          ]
      }

      {
          name: GPIO_6_CFG
          desc: '''
            Pad signal configuration.
          '''
          swaccess: "rw"
          fields: [
            {
                bits: "0"
                name: chip2pad
                desc: '''
                     Signal to connect internal Chip to the TX driver of the Pad
                '''
                swaccess: "rw"
                hwaccess: "hro"
                resval: "0"
            },
            {
                bits: "2:1"
                name: drv
                desc: '''
                     Driving Strength selector
                '''
                swaccess: "rw"
                hwaccess: "hro"
                resval: "3"
            },
            {
                bits: "3"
                name: pde
                desc: '''
                     Pull-Down resistor Enable
                '''
                swaccess: "rw"
                hwaccess: "hro"
                resval: "0"
            },
            {
                bits: "4"
                name: pue
                desc: '''
                     Pull-Up resistor Enable
                '''
                swaccess: "rw"
                hwaccess: "hro"
                resval: "0"
            },
            {
                bits: "5"
                name: rxe
                desc: '''
                     Active high RX enable
                '''
                swaccess: "rw"
                hwaccess: "hro"
                resval: "0"
            },
            {
                bits: "6"
                name: slw
                desc: '''
                     
                '''
                swaccess: "rw"
                hwaccess: "hro"
                resval: "0"
            },
            {
                bits: "7"
                name: smt
                desc: '''
                     Active High schmidt trigger Enable
                '''
                swaccess: "rw"
                hwaccess: "hro"
                resval: "0"
            },
            {
                bits: "8"
                name: trie
                desc: '''
                     Active high tri-state enable: trie = 1 -> buffer is in tri-state mode, i.e. Hi-Z. To Transmit trie = 0
                '''
                swaccess: "rw"
                hwaccess: "hro"
                resval: "1"
            },
          ]
      }

       {
          name: GPIO_6_MUX_SEL
          desc: '''
              Pad signal port multiplex selection for pad gpio_6. The programmed value defines which port
              is connected to the pad.
          '''
          swaccess: "rw"
          hwaccess: "hro"
          resval: 0
          fields: [
              {
                  bits: "3:0"
                  enum: [
                      { value: "0", name: "register", desc: "Connects the Pad to the internal configuration register."}
                      { value: "1", name: "port_i2c0_scl", desc: "Connect port scl from port group i2c0 to this pad." }
                      { value: "2", name: "port_i2c0_sda", desc: "Connect port sda from port group i2c0 to this pad." }
                      { value: "3", name: "port_qspi0_csb0", desc: "Connect port csb0 from port group qspi0 to this pad." }
                      { value: "4", name: "port_qspi0_csb1", desc: "Connect port csb1 from port group qspi0 to this pad." }
                      { value: "5", name: "port_qspi0_csb2", desc: "Connect port csb2 from port group qspi0 to this pad." }
                      { value: "6", name: "port_qspi0_sck", desc: "Connect port sck from port group qspi0 to this pad." }
                      { value: "7", name: "port_qspi0_sd0", desc: "Connect port sd0 from port group qspi0 to this pad." }
                      { value: "8", name: "port_qspi0_sd1", desc: "Connect port sd1 from port group qspi0 to this pad." }
                      { value: "9", name: "port_qspi0_sd2", desc: "Connect port sd2 from port group qspi0 to this pad." }
                      { value: "10", name: "port_qspi0_sd3", desc: "Connect port sd3 from port group qspi0 to this pad." }
                      { value: "11", name: "port_uart0_rx", desc: "Connect port rx from port group uart0 to this pad." }
                      { value: "12", name: "port_uart0_tx", desc: "Connect port tx from port group uart0 to this pad." }
                  ]
              }
          ]
      }

      {
          name: GPIO_7_CFG
          desc: '''
            Pad signal configuration.
          '''
          swaccess: "rw"
          fields: [
            {
                bits: "0"
                name: chip2pad
                desc: '''
                     Signal to connect internal Chip to the TX driver of the Pad
                '''
                swaccess: "rw"
                hwaccess: "hro"
                resval: "0"
            },
            {
                bits: "2:1"
                name: drv
                desc: '''
                     Driving Strength selector
                '''
                swaccess: "rw"
                hwaccess: "hro"
                resval: "3"
            },
            {
                bits: "3"
                name: pde
                desc: '''
                     Pull-Down resistor Enable
                '''
                swaccess: "rw"
                hwaccess: "hro"
                resval: "0"
            },
            {
                bits: "4"
                name: pue
                desc: '''
                     Pull-Up resistor Enable
                '''
                swaccess: "rw"
                hwaccess: "hro"
                resval: "0"
            },
            {
                bits: "5"
                name: rxe
                desc: '''
                     Active high RX enable
                '''
                swaccess: "rw"
                hwaccess: "hro"
                resval: "0"
            },
            {
                bits: "6"
                name: slw
                desc: '''
                     
                '''
                swaccess: "rw"
                hwaccess: "hro"
                resval: "0"
            },
            {
                bits: "7"
                name: smt
                desc: '''
                     Active High schmidt trigger Enable
                '''
                swaccess: "rw"
                hwaccess: "hro"
                resval: "0"
            },
            {
                bits: "8"
                name: trie
                desc: '''
                     Active high tri-state enable: trie = 1 -> buffer is in tri-state mode, i.e. Hi-Z. To Transmit trie = 0
                '''
                swaccess: "rw"
                hwaccess: "hro"
                resval: "1"
            },
          ]
      }

       {
          name: GPIO_7_MUX_SEL
          desc: '''
              Pad signal port multiplex selection for pad gpio_7. The programmed value defines which port
              is connected to the pad.
          '''
          swaccess: "rw"
          hwaccess: "hro"
          resval: 0
          fields: [
              {
                  bits: "3:0"
                  enum: [
                      { value: "0", name: "register", desc: "Connects the Pad to the internal configuration register."}
                      { value: "1", name: "port_i2c0_scl", desc: "Connect port scl from port group i2c0 to this pad." }
                      { value: "2", name: "port_i2c0_sda", desc: "Connect port sda from port group i2c0 to this pad." }
                      { value: "3", name: "port_qspi0_csb0", desc: "Connect port csb0 from port group qspi0 to this pad." }
                      { value: "4", name: "port_qspi0_csb1", desc: "Connect port csb1 from port group qspi0 to this pad." }
                      { value: "5", name: "port_qspi0_csb2", desc: "Connect port csb2 from port group qspi0 to this pad." }
                      { value: "6", name: "port_qspi0_sck", desc: "Connect port sck from port group qspi0 to this pad." }
                      { value: "7", name: "port_qspi0_sd0", desc: "Connect port sd0 from port group qspi0 to this pad." }
                      { value: "8", name: "port_qspi0_sd1", desc: "Connect port sd1 from port group qspi0 to this pad." }
                      { value: "9", name: "port_qspi0_sd2", desc: "Connect port sd2 from port group qspi0 to this pad." }
                      { value: "10", name: "port_qspi0_sd3", desc: "Connect port sd3 from port group qspi0 to this pad." }
                      { value: "11", name: "port_uart0_rx", desc: "Connect port rx from port group uart0 to this pad." }
                      { value: "12", name: "port_uart0_tx", desc: "Connect port tx from port group uart0 to this pad." }
                  ]
              }
          ]
      }

      {
          name: GPIO_8_CFG
          desc: '''
            Pad signal configuration.
          '''
          swaccess: "rw"
          fields: [
            {
                bits: "0"
                name: chip2pad
                desc: '''
                     Signal to connect internal Chip to the TX driver of the Pad
                '''
                swaccess: "rw"
                hwaccess: "hro"
                resval: "0"
            },
            {
                bits: "2:1"
                name: drv
                desc: '''
                     Driving Strength selector
                '''
                swaccess: "rw"
                hwaccess: "hro"
                resval: "3"
            },
            {
                bits: "3"
                name: pde
                desc: '''
                     Pull-Down resistor Enable
                '''
                swaccess: "rw"
                hwaccess: "hro"
                resval: "0"
            },
            {
                bits: "4"
                name: pue
                desc: '''
                     Pull-Up resistor Enable
                '''
                swaccess: "rw"
                hwaccess: "hro"
                resval: "0"
            },
            {
                bits: "5"
                name: rxe
                desc: '''
                     Active high RX enable
                '''
                swaccess: "rw"
                hwaccess: "hro"
                resval: "0"
            },
            {
                bits: "6"
                name: slw
                desc: '''
                     
                '''
                swaccess: "rw"
                hwaccess: "hro"
                resval: "0"
            },
            {
                bits: "7"
                name: smt
                desc: '''
                     Active High schmidt trigger Enable
                '''
                swaccess: "rw"
                hwaccess: "hro"
                resval: "0"
            },
            {
                bits: "8"
                name: trie
                desc: '''
                     Active high tri-state enable: trie = 1 -> buffer is in tri-state mode, i.e. Hi-Z. To Transmit trie = 0
                '''
                swaccess: "rw"
                hwaccess: "hro"
                resval: "1"
            },
          ]
      }

       {
          name: GPIO_8_MUX_SEL
          desc: '''
              Pad signal port multiplex selection for pad gpio_8. The programmed value defines which port
              is connected to the pad.
          '''
          swaccess: "rw"
          hwaccess: "hro"
          resval: 0
          fields: [
              {
                  bits: "3:0"
                  enum: [
                      { value: "0", name: "register", desc: "Connects the Pad to the internal configuration register."}
                      { value: "1", name: "port_i2c0_scl", desc: "Connect port scl from port group i2c0 to this pad." }
                      { value: "2", name: "port_i2c0_sda", desc: "Connect port sda from port group i2c0 to this pad." }
                      { value: "3", name: "port_qspi0_csb0", desc: "Connect port csb0 from port group qspi0 to this pad." }
                      { value: "4", name: "port_qspi0_csb1", desc: "Connect port csb1 from port group qspi0 to this pad." }
                      { value: "5", name: "port_qspi0_csb2", desc: "Connect port csb2 from port group qspi0 to this pad." }
                      { value: "6", name: "port_qspi0_sck", desc: "Connect port sck from port group qspi0 to this pad." }
                      { value: "7", name: "port_qspi0_sd0", desc: "Connect port sd0 from port group qspi0 to this pad." }
                      { value: "8", name: "port_qspi0_sd1", desc: "Connect port sd1 from port group qspi0 to this pad." }
                      { value: "9", name: "port_qspi0_sd2", desc: "Connect port sd2 from port group qspi0 to this pad." }
                      { value: "10", name: "port_qspi0_sd3", desc: "Connect port sd3 from port group qspi0 to this pad." }
                      { value: "11", name: "port_uart0_rx", desc: "Connect port rx from port group uart0 to this pad." }
                      { value: "12", name: "port_uart0_tx", desc: "Connect port tx from port group uart0 to this pad." }
                  ]
              }
          ]
      }

      {
          name: GPIO_9_CFG
          desc: '''
            Pad signal configuration.
          '''
          swaccess: "rw"
          fields: [
            {
                bits: "0"
                name: chip2pad
                desc: '''
                     Signal to connect internal Chip to the TX driver of the Pad
                '''
                swaccess: "rw"
                hwaccess: "hro"
                resval: "0"
            },
            {
                bits: "2:1"
                name: drv
                desc: '''
                     Driving Strength selector
                '''
                swaccess: "rw"
                hwaccess: "hro"
                resval: "3"
            },
            {
                bits: "3"
                name: pde
                desc: '''
                     Pull-Down resistor Enable
                '''
                swaccess: "rw"
                hwaccess: "hro"
                resval: "0"
            },
            {
                bits: "4"
                name: pue
                desc: '''
                     Pull-Up resistor Enable
                '''
                swaccess: "rw"
                hwaccess: "hro"
                resval: "0"
            },
            {
                bits: "5"
                name: rxe
                desc: '''
                     Active high RX enable
                '''
                swaccess: "rw"
                hwaccess: "hro"
                resval: "0"
            },
            {
                bits: "6"
                name: slw
                desc: '''
                     
                '''
                swaccess: "rw"
                hwaccess: "hro"
                resval: "0"
            },
            {
                bits: "7"
                name: smt
                desc: '''
                     Active High schmidt trigger Enable
                '''
                swaccess: "rw"
                hwaccess: "hro"
                resval: "0"
            },
            {
                bits: "8"
                name: trie
                desc: '''
                     Active high tri-state enable: trie = 1 -> buffer is in tri-state mode, i.e. Hi-Z. To Transmit trie = 0
                '''
                swaccess: "rw"
                hwaccess: "hro"
                resval: "1"
            },
          ]
      }

       {
          name: GPIO_9_MUX_SEL
          desc: '''
              Pad signal port multiplex selection for pad gpio_9. The programmed value defines which port
              is connected to the pad.
          '''
          swaccess: "rw"
          hwaccess: "hro"
          resval: 0
          fields: [
              {
                  bits: "3:0"
                  enum: [
                      { value: "0", name: "register", desc: "Connects the Pad to the internal configuration register."}
                      { value: "1", name: "port_i2c0_scl", desc: "Connect port scl from port group i2c0 to this pad." }
                      { value: "2", name: "port_i2c0_sda", desc: "Connect port sda from port group i2c0 to this pad." }
                      { value: "3", name: "port_qspi0_csb0", desc: "Connect port csb0 from port group qspi0 to this pad." }
                      { value: "4", name: "port_qspi0_csb1", desc: "Connect port csb1 from port group qspi0 to this pad." }
                      { value: "5", name: "port_qspi0_csb2", desc: "Connect port csb2 from port group qspi0 to this pad." }
                      { value: "6", name: "port_qspi0_sck", desc: "Connect port sck from port group qspi0 to this pad." }
                      { value: "7", name: "port_qspi0_sd0", desc: "Connect port sd0 from port group qspi0 to this pad." }
                      { value: "8", name: "port_qspi0_sd1", desc: "Connect port sd1 from port group qspi0 to this pad." }
                      { value: "9", name: "port_qspi0_sd2", desc: "Connect port sd2 from port group qspi0 to this pad." }
                      { value: "10", name: "port_qspi0_sd3", desc: "Connect port sd3 from port group qspi0 to this pad." }
                      { value: "11", name: "port_uart0_rx", desc: "Connect port rx from port group uart0 to this pad." }
                      { value: "12", name: "port_uart0_tx", desc: "Connect port tx from port group uart0 to this pad." }
                  ]
              }
          ]
      }

      {
          name: GPIO_10_CFG
          desc: '''
            Pad signal configuration.
          '''
          swaccess: "rw"
          fields: [
            {
                bits: "0"
                name: chip2pad
                desc: '''
                     Signal to connect internal Chip to the TX driver of the Pad
                '''
                swaccess: "rw"
                hwaccess: "hro"
                resval: "0"
            },
            {
                bits: "2:1"
                name: drv
                desc: '''
                     Driving Strength selector
                '''
                swaccess: "rw"
                hwaccess: "hro"
                resval: "3"
            },
            {
                bits: "3"
                name: pde
                desc: '''
                     Pull-Down resistor Enable
                '''
                swaccess: "rw"
                hwaccess: "hro"
                resval: "0"
            },
            {
                bits: "4"
                name: pue
                desc: '''
                     Pull-Up resistor Enable
                '''
                swaccess: "rw"
                hwaccess: "hro"
                resval: "0"
            },
            {
                bits: "5"
                name: rxe
                desc: '''
                     Active high RX enable
                '''
                swaccess: "rw"
                hwaccess: "hro"
                resval: "0"
            },
            {
                bits: "6"
                name: slw
                desc: '''
                     
                '''
                swaccess: "rw"
                hwaccess: "hro"
                resval: "0"
            },
            {
                bits: "7"
                name: smt
                desc: '''
                     Active High schmidt trigger Enable
                '''
                swaccess: "rw"
                hwaccess: "hro"
                resval: "0"
            },
            {
                bits: "8"
                name: trie
                desc: '''
                     Active high tri-state enable: trie = 1 -> buffer is in tri-state mode, i.e. Hi-Z. To Transmit trie = 0
                '''
                swaccess: "rw"
                hwaccess: "hro"
                resval: "1"
            },
          ]
      }

       {
          name: GPIO_10_MUX_SEL
          desc: '''
              Pad signal port multiplex selection for pad gpio_10. The programmed value defines which port
              is connected to the pad.
          '''
          swaccess: "rw"
          hwaccess: "hro"
          resval: 0
          fields: [
              {
                  bits: "3:0"
                  enum: [
                      { value: "0", name: "register", desc: "Connects the Pad to the internal configuration register."}
                      { value: "1", name: "port_i2c0_scl", desc: "Connect port scl from port group i2c0 to this pad." }
                      { value: "2", name: "port_i2c0_sda", desc: "Connect port sda from port group i2c0 to this pad." }
                      { value: "3", name: "port_qspi0_csb0", desc: "Connect port csb0 from port group qspi0 to this pad." }
                      { value: "4", name: "port_qspi0_csb1", desc: "Connect port csb1 from port group qspi0 to this pad." }
                      { value: "5", name: "port_qspi0_csb2", desc: "Connect port csb2 from port group qspi0 to this pad." }
                      { value: "6", name: "port_qspi0_sck", desc: "Connect port sck from port group qspi0 to this pad." }
                      { value: "7", name: "port_qspi0_sd0", desc: "Connect port sd0 from port group qspi0 to this pad." }
                      { value: "8", name: "port_qspi0_sd1", desc: "Connect port sd1 from port group qspi0 to this pad." }
                      { value: "9", name: "port_qspi0_sd2", desc: "Connect port sd2 from port group qspi0 to this pad." }
                      { value: "10", name: "port_qspi0_sd3", desc: "Connect port sd3 from port group qspi0 to this pad." }
                      { value: "11", name: "port_uart0_rx", desc: "Connect port rx from port group uart0 to this pad." }
                      { value: "12", name: "port_uart0_tx", desc: "Connect port tx from port group uart0 to this pad." }
                  ]
              }
          ]
      }

      {
          name: GPIO_11_CFG
          desc: '''
            Pad signal configuration.
          '''
          swaccess: "rw"
          fields: [
            {
                bits: "0"
                name: chip2pad
                desc: '''
                     Signal to connect internal Chip to the TX driver of the Pad
                '''
                swaccess: "rw"
                hwaccess: "hro"
                resval: "0"
            },
            {
                bits: "2:1"
                name: drv
                desc: '''
                     Driving Strength selector
                '''
                swaccess: "rw"
                hwaccess: "hro"
                resval: "3"
            },
            {
                bits: "3"
                name: pde
                desc: '''
                     Pull-Down resistor Enable
                '''
                swaccess: "rw"
                hwaccess: "hro"
                resval: "0"
            },
            {
                bits: "4"
                name: pue
                desc: '''
                     Pull-Up resistor Enable
                '''
                swaccess: "rw"
                hwaccess: "hro"
                resval: "0"
            },
            {
                bits: "5"
                name: rxe
                desc: '''
                     Active high RX enable
                '''
                swaccess: "rw"
                hwaccess: "hro"
                resval: "0"
            },
            {
                bits: "6"
                name: slw
                desc: '''
                     
                '''
                swaccess: "rw"
                hwaccess: "hro"
                resval: "0"
            },
            {
                bits: "7"
                name: smt
                desc: '''
                     Active High schmidt trigger Enable
                '''
                swaccess: "rw"
                hwaccess: "hro"
                resval: "0"
            },
            {
                bits: "8"
                name: trie
                desc: '''
                     Active high tri-state enable: trie = 1 -> buffer is in tri-state mode, i.e. Hi-Z. To Transmit trie = 0
                '''
                swaccess: "rw"
                hwaccess: "hro"
                resval: "1"
            },
          ]
      }

       {
          name: GPIO_11_MUX_SEL
          desc: '''
              Pad signal port multiplex selection for pad gpio_11. The programmed value defines which port
              is connected to the pad.
          '''
          swaccess: "rw"
          hwaccess: "hro"
          resval: 0
          fields: [
              {
                  bits: "3:0"
                  enum: [
                      { value: "0", name: "register", desc: "Connects the Pad to the internal configuration register."}
                      { value: "1", name: "port_i2c0_scl", desc: "Connect port scl from port group i2c0 to this pad." }
                      { value: "2", name: "port_i2c0_sda", desc: "Connect port sda from port group i2c0 to this pad." }
                      { value: "3", name: "port_qspi0_csb0", desc: "Connect port csb0 from port group qspi0 to this pad." }
                      { value: "4", name: "port_qspi0_csb1", desc: "Connect port csb1 from port group qspi0 to this pad." }
                      { value: "5", name: "port_qspi0_csb2", desc: "Connect port csb2 from port group qspi0 to this pad." }
                      { value: "6", name: "port_qspi0_sck", desc: "Connect port sck from port group qspi0 to this pad." }
                      { value: "7", name: "port_qspi0_sd0", desc: "Connect port sd0 from port group qspi0 to this pad." }
                      { value: "8", name: "port_qspi0_sd1", desc: "Connect port sd1 from port group qspi0 to this pad." }
                      { value: "9", name: "port_qspi0_sd2", desc: "Connect port sd2 from port group qspi0 to this pad." }
                      { value: "10", name: "port_qspi0_sd3", desc: "Connect port sd3 from port group qspi0 to this pad." }
                      { value: "11", name: "port_uart0_rx", desc: "Connect port rx from port group uart0 to this pad." }
                      { value: "12", name: "port_uart0_tx", desc: "Connect port tx from port group uart0 to this pad." }
                  ]
              }
          ]
      }

      {
          name: GPIO_12_CFG
          desc: '''
            Pad signal configuration.
          '''
          swaccess: "rw"
          fields: [
            {
                bits: "0"
                name: chip2pad
                desc: '''
                     Signal to connect internal Chip to the TX driver of the Pad
                '''
                swaccess: "rw"
                hwaccess: "hro"
                resval: "0"
            },
            {
                bits: "2:1"
                name: drv
                desc: '''
                     Driving Strength selector
                '''
                swaccess: "rw"
                hwaccess: "hro"
                resval: "3"
            },
            {
                bits: "3"
                name: pde
                desc: '''
                     Pull-Down resistor Enable
                '''
                swaccess: "rw"
                hwaccess: "hro"
                resval: "0"
            },
            {
                bits: "4"
                name: pue
                desc: '''
                     Pull-Up resistor Enable
                '''
                swaccess: "rw"
                hwaccess: "hro"
                resval: "0"
            },
            {
                bits: "5"
                name: rxe
                desc: '''
                     Active high RX enable
                '''
                swaccess: "rw"
                hwaccess: "hro"
                resval: "0"
            },
            {
                bits: "6"
                name: slw
                desc: '''
                     
                '''
                swaccess: "rw"
                hwaccess: "hro"
                resval: "0"
            },
            {
                bits: "7"
                name: smt
                desc: '''
                     Active High schmidt trigger Enable
                '''
                swaccess: "rw"
                hwaccess: "hro"
                resval: "0"
            },
            {
                bits: "8"
                name: trie
                desc: '''
                     Active high tri-state enable: trie = 1 -> buffer is in tri-state mode, i.e. Hi-Z. To Transmit trie = 0
                '''
                swaccess: "rw"
                hwaccess: "hro"
                resval: "1"
            },
          ]
      }

       {
          name: GPIO_12_MUX_SEL
          desc: '''
              Pad signal port multiplex selection for pad gpio_12. The programmed value defines which port
              is connected to the pad.
          '''
          swaccess: "rw"
          hwaccess: "hro"
          resval: 0
          fields: [
              {
                  bits: "3:0"
                  enum: [
                      { value: "0", name: "register", desc: "Connects the Pad to the internal configuration register."}
                      { value: "1", name: "port_i2c0_scl", desc: "Connect port scl from port group i2c0 to this pad." }
                      { value: "2", name: "port_i2c0_sda", desc: "Connect port sda from port group i2c0 to this pad." }
                      { value: "3", name: "port_qspi0_csb0", desc: "Connect port csb0 from port group qspi0 to this pad." }
                      { value: "4", name: "port_qspi0_csb1", desc: "Connect port csb1 from port group qspi0 to this pad." }
                      { value: "5", name: "port_qspi0_csb2", desc: "Connect port csb2 from port group qspi0 to this pad." }
                      { value: "6", name: "port_qspi0_sck", desc: "Connect port sck from port group qspi0 to this pad." }
                      { value: "7", name: "port_qspi0_sd0", desc: "Connect port sd0 from port group qspi0 to this pad." }
                      { value: "8", name: "port_qspi0_sd1", desc: "Connect port sd1 from port group qspi0 to this pad." }
                      { value: "9", name: "port_qspi0_sd2", desc: "Connect port sd2 from port group qspi0 to this pad." }
                      { value: "10", name: "port_qspi0_sd3", desc: "Connect port sd3 from port group qspi0 to this pad." }
                      { value: "11", name: "port_uart0_rx", desc: "Connect port rx from port group uart0 to this pad." }
                      { value: "12", name: "port_uart0_tx", desc: "Connect port tx from port group uart0 to this pad." }
                  ]
              }
          ]
      }

      {
          name: GPIO_13_CFG
          desc: '''
            Pad signal configuration.
          '''
          swaccess: "rw"
          fields: [
            {
                bits: "0"
                name: chip2pad
                desc: '''
                     Signal to connect internal Chip to the TX driver of the Pad
                '''
                swaccess: "rw"
                hwaccess: "hro"
                resval: "0"
            },
            {
                bits: "2:1"
                name: drv
                desc: '''
                     Driving Strength selector
                '''
                swaccess: "rw"
                hwaccess: "hro"
                resval: "3"
            },
            {
                bits: "3"
                name: pde
                desc: '''
                     Pull-Down resistor Enable
                '''
                swaccess: "rw"
                hwaccess: "hro"
                resval: "0"
            },
            {
                bits: "4"
                name: pue
                desc: '''
                     Pull-Up resistor Enable
                '''
                swaccess: "rw"
                hwaccess: "hro"
                resval: "0"
            },
            {
                bits: "5"
                name: rxe
                desc: '''
                     Active high RX enable
                '''
                swaccess: "rw"
                hwaccess: "hro"
                resval: "0"
            },
            {
                bits: "6"
                name: slw
                desc: '''
                     
                '''
                swaccess: "rw"
                hwaccess: "hro"
                resval: "0"
            },
            {
                bits: "7"
                name: smt
                desc: '''
                     Active High schmidt trigger Enable
                '''
                swaccess: "rw"
                hwaccess: "hro"
                resval: "0"
            },
            {
                bits: "8"
                name: trie
                desc: '''
                     Active high tri-state enable: trie = 1 -> buffer is in tri-state mode, i.e. Hi-Z. To Transmit trie = 0
                '''
                swaccess: "rw"
                hwaccess: "hro"
                resval: "1"
            },
          ]
      }

       {
          name: GPIO_13_MUX_SEL
          desc: '''
              Pad signal port multiplex selection for pad gpio_13. The programmed value defines which port
              is connected to the pad.
          '''
          swaccess: "rw"
          hwaccess: "hro"
          resval: 0
          fields: [
              {
                  bits: "3:0"
                  enum: [
                      { value: "0", name: "register", desc: "Connects the Pad to the internal configuration register."}
                      { value: "1", name: "port_i2c0_scl", desc: "Connect port scl from port group i2c0 to this pad." }
                      { value: "2", name: "port_i2c0_sda", desc: "Connect port sda from port group i2c0 to this pad." }
                      { value: "3", name: "port_qspi0_csb0", desc: "Connect port csb0 from port group qspi0 to this pad." }
                      { value: "4", name: "port_qspi0_csb1", desc: "Connect port csb1 from port group qspi0 to this pad." }
                      { value: "5", name: "port_qspi0_csb2", desc: "Connect port csb2 from port group qspi0 to this pad." }
                      { value: "6", name: "port_qspi0_sck", desc: "Connect port sck from port group qspi0 to this pad." }
                      { value: "7", name: "port_qspi0_sd0", desc: "Connect port sd0 from port group qspi0 to this pad." }
                      { value: "8", name: "port_qspi0_sd1", desc: "Connect port sd1 from port group qspi0 to this pad." }
                      { value: "9", name: "port_qspi0_sd2", desc: "Connect port sd2 from port group qspi0 to this pad." }
                      { value: "10", name: "port_qspi0_sd3", desc: "Connect port sd3 from port group qspi0 to this pad." }
                      { value: "11", name: "port_uart0_rx", desc: "Connect port rx from port group uart0 to this pad." }
                      { value: "12", name: "port_uart0_tx", desc: "Connect port tx from port group uart0 to this pad." }
                  ]
              }
          ]
      }

      {
          name: GPIO_14_CFG
          desc: '''
            Pad signal configuration.
          '''
          swaccess: "rw"
          fields: [
            {
                bits: "0"
                name: chip2pad
                desc: '''
                     Signal to connect internal Chip to the TX driver of the Pad
                '''
                swaccess: "rw"
                hwaccess: "hro"
                resval: "0"
            },
            {
                bits: "2:1"
                name: drv
                desc: '''
                     Driving Strength selector
                '''
                swaccess: "rw"
                hwaccess: "hro"
                resval: "3"
            },
            {
                bits: "3"
                name: pde
                desc: '''
                     Pull-Down resistor Enable
                '''
                swaccess: "rw"
                hwaccess: "hro"
                resval: "0"
            },
            {
                bits: "4"
                name: pue
                desc: '''
                     Pull-Up resistor Enable
                '''
                swaccess: "rw"
                hwaccess: "hro"
                resval: "0"
            },
            {
                bits: "5"
                name: rxe
                desc: '''
                     Active high RX enable
                '''
                swaccess: "rw"
                hwaccess: "hro"
                resval: "0"
            },
            {
                bits: "6"
                name: slw
                desc: '''
                     
                '''
                swaccess: "rw"
                hwaccess: "hro"
                resval: "0"
            },
            {
                bits: "7"
                name: smt
                desc: '''
                     Active High schmidt trigger Enable
                '''
                swaccess: "rw"
                hwaccess: "hro"
                resval: "0"
            },
            {
                bits: "8"
                name: trie
                desc: '''
                     Active high tri-state enable: trie = 1 -> buffer is in tri-state mode, i.e. Hi-Z. To Transmit trie = 0
                '''
                swaccess: "rw"
                hwaccess: "hro"
                resval: "1"
            },
          ]
      }

       {
          name: GPIO_14_MUX_SEL
          desc: '''
              Pad signal port multiplex selection for pad gpio_14. The programmed value defines which port
              is connected to the pad.
          '''
          swaccess: "rw"
          hwaccess: "hro"
          resval: 0
          fields: [
              {
                  bits: "3:0"
                  enum: [
                      { value: "0", name: "register", desc: "Connects the Pad to the internal configuration register."}
                      { value: "1", name: "port_i2c0_scl", desc: "Connect port scl from port group i2c0 to this pad." }
                      { value: "2", name: "port_i2c0_sda", desc: "Connect port sda from port group i2c0 to this pad." }
                      { value: "3", name: "port_qspi0_csb0", desc: "Connect port csb0 from port group qspi0 to this pad." }
                      { value: "4", name: "port_qspi0_csb1", desc: "Connect port csb1 from port group qspi0 to this pad." }
                      { value: "5", name: "port_qspi0_csb2", desc: "Connect port csb2 from port group qspi0 to this pad." }
                      { value: "6", name: "port_qspi0_sck", desc: "Connect port sck from port group qspi0 to this pad." }
                      { value: "7", name: "port_qspi0_sd0", desc: "Connect port sd0 from port group qspi0 to this pad." }
                      { value: "8", name: "port_qspi0_sd1", desc: "Connect port sd1 from port group qspi0 to this pad." }
                      { value: "9", name: "port_qspi0_sd2", desc: "Connect port sd2 from port group qspi0 to this pad." }
                      { value: "10", name: "port_qspi0_sd3", desc: "Connect port sd3 from port group qspi0 to this pad." }
                      { value: "11", name: "port_uart0_rx", desc: "Connect port rx from port group uart0 to this pad." }
                      { value: "12", name: "port_uart0_tx", desc: "Connect port tx from port group uart0 to this pad." }
                  ]
              }
          ]
      }

      {
          name: GPIO_15_CFG
          desc: '''
            Pad signal configuration.
          '''
          swaccess: "rw"
          fields: [
            {
                bits: "0"
                name: chip2pad
                desc: '''
                     Signal to connect internal Chip to the TX driver of the Pad
                '''
                swaccess: "rw"
                hwaccess: "hro"
                resval: "0"
            },
            {
                bits: "2:1"
                name: drv
                desc: '''
                     Driving Strength selector
                '''
                swaccess: "rw"
                hwaccess: "hro"
                resval: "3"
            },
            {
                bits: "3"
                name: pde
                desc: '''
                     Pull-Down resistor Enable
                '''
                swaccess: "rw"
                hwaccess: "hro"
                resval: "0"
            },
            {
                bits: "4"
                name: pue
                desc: '''
                     Pull-Up resistor Enable
                '''
                swaccess: "rw"
                hwaccess: "hro"
                resval: "0"
            },
            {
                bits: "5"
                name: rxe
                desc: '''
                     Active high RX enable
                '''
                swaccess: "rw"
                hwaccess: "hro"
                resval: "0"
            },
            {
                bits: "6"
                name: slw
                desc: '''
                     
                '''
                swaccess: "rw"
                hwaccess: "hro"
                resval: "0"
            },
            {
                bits: "7"
                name: smt
                desc: '''
                     Active High schmidt trigger Enable
                '''
                swaccess: "rw"
                hwaccess: "hro"
                resval: "0"
            },
            {
                bits: "8"
                name: trie
                desc: '''
                     Active high tri-state enable: trie = 1 -> buffer is in tri-state mode, i.e. Hi-Z. To Transmit trie = 0
                '''
                swaccess: "rw"
                hwaccess: "hro"
                resval: "1"
            },
          ]
      }

       {
          name: GPIO_15_MUX_SEL
          desc: '''
              Pad signal port multiplex selection for pad gpio_15. The programmed value defines which port
              is connected to the pad.
          '''
          swaccess: "rw"
          hwaccess: "hro"
          resval: 0
          fields: [
              {
                  bits: "3:0"
                  enum: [
                      { value: "0", name: "register", desc: "Connects the Pad to the internal configuration register."}
                      { value: "1", name: "port_i2c0_scl", desc: "Connect port scl from port group i2c0 to this pad." }
                      { value: "2", name: "port_i2c0_sda", desc: "Connect port sda from port group i2c0 to this pad." }
                      { value: "3", name: "port_qspi0_csb0", desc: "Connect port csb0 from port group qspi0 to this pad." }
                      { value: "4", name: "port_qspi0_csb1", desc: "Connect port csb1 from port group qspi0 to this pad." }
                      { value: "5", name: "port_qspi0_csb2", desc: "Connect port csb2 from port group qspi0 to this pad." }
                      { value: "6", name: "port_qspi0_sck", desc: "Connect port sck from port group qspi0 to this pad." }
                      { value: "7", name: "port_qspi0_sd0", desc: "Connect port sd0 from port group qspi0 to this pad." }
                      { value: "8", name: "port_qspi0_sd1", desc: "Connect port sd1 from port group qspi0 to this pad." }
                      { value: "9", name: "port_qspi0_sd2", desc: "Connect port sd2 from port group qspi0 to this pad." }
                      { value: "10", name: "port_qspi0_sd3", desc: "Connect port sd3 from port group qspi0 to this pad." }
                      { value: "11", name: "port_uart0_rx", desc: "Connect port rx from port group uart0 to this pad." }
                      { value: "12", name: "port_uart0_tx", desc: "Connect port tx from port group uart0 to this pad." }
                  ]
              }
          ]
      }

      {
          name: GPIO_16_CFG
          desc: '''
            Pad signal configuration.
          '''
          swaccess: "rw"
          fields: [
            {
                bits: "0"
                name: chip2pad
                desc: '''
                     Signal to connect internal Chip to the TX driver of the Pad
                '''
                swaccess: "rw"
                hwaccess: "hro"
                resval: "0"
            },
            {
                bits: "2:1"
                name: drv
                desc: '''
                     Driving Strength selector
                '''
                swaccess: "rw"
                hwaccess: "hro"
                resval: "3"
            },
            {
                bits: "3"
                name: pde
                desc: '''
                     Pull-Down resistor Enable
                '''
                swaccess: "rw"
                hwaccess: "hro"
                resval: "0"
            },
            {
                bits: "4"
                name: pue
                desc: '''
                     Pull-Up resistor Enable
                '''
                swaccess: "rw"
                hwaccess: "hro"
                resval: "0"
            },
            {
                bits: "5"
                name: rxe
                desc: '''
                     Active high RX enable
                '''
                swaccess: "rw"
                hwaccess: "hro"
                resval: "0"
            },
            {
                bits: "6"
                name: slw
                desc: '''
                     
                '''
                swaccess: "rw"
                hwaccess: "hro"
                resval: "0"
            },
            {
                bits: "7"
                name: smt
                desc: '''
                     Active High schmidt trigger Enable
                '''
                swaccess: "rw"
                hwaccess: "hro"
                resval: "0"
            },
            {
                bits: "8"
                name: trie
                desc: '''
                     Active high tri-state enable: trie = 1 -> buffer is in tri-state mode, i.e. Hi-Z. To Transmit trie = 0
                '''
                swaccess: "rw"
                hwaccess: "hro"
                resval: "1"
            },
          ]
      }

       {
          name: GPIO_16_MUX_SEL
          desc: '''
              Pad signal port multiplex selection for pad gpio_16. The programmed value defines which port
              is connected to the pad.
          '''
          swaccess: "rw"
          hwaccess: "hro"
          resval: 0
          fields: [
              {
                  bits: "3:0"
                  enum: [
                      { value: "0", name: "register", desc: "Connects the Pad to the internal configuration register."}
                      { value: "1", name: "port_i2c0_scl", desc: "Connect port scl from port group i2c0 to this pad." }
                      { value: "2", name: "port_i2c0_sda", desc: "Connect port sda from port group i2c0 to this pad." }
                      { value: "3", name: "port_qspi0_csb0", desc: "Connect port csb0 from port group qspi0 to this pad." }
                      { value: "4", name: "port_qspi0_csb1", desc: "Connect port csb1 from port group qspi0 to this pad." }
                      { value: "5", name: "port_qspi0_csb2", desc: "Connect port csb2 from port group qspi0 to this pad." }
                      { value: "6", name: "port_qspi0_sck", desc: "Connect port sck from port group qspi0 to this pad." }
                      { value: "7", name: "port_qspi0_sd0", desc: "Connect port sd0 from port group qspi0 to this pad." }
                      { value: "8", name: "port_qspi0_sd1", desc: "Connect port sd1 from port group qspi0 to this pad." }
                      { value: "9", name: "port_qspi0_sd2", desc: "Connect port sd2 from port group qspi0 to this pad." }
                      { value: "10", name: "port_qspi0_sd3", desc: "Connect port sd3 from port group qspi0 to this pad." }
                      { value: "11", name: "port_uart0_rx", desc: "Connect port rx from port group uart0 to this pad." }
                      { value: "12", name: "port_uart0_tx", desc: "Connect port tx from port group uart0 to this pad." }
                  ]
              }
          ]
      }

      {
          name: GPIO_17_CFG
          desc: '''
            Pad signal configuration.
          '''
          swaccess: "rw"
          fields: [
            {
                bits: "0"
                name: chip2pad
                desc: '''
                     Signal to connect internal Chip to the TX driver of the Pad
                '''
                swaccess: "rw"
                hwaccess: "hro"
                resval: "0"
            },
            {
                bits: "2:1"
                name: drv
                desc: '''
                     Driving Strength selector
                '''
                swaccess: "rw"
                hwaccess: "hro"
                resval: "3"
            },
            {
                bits: "3"
                name: pde
                desc: '''
                     Pull-Down resistor Enable
                '''
                swaccess: "rw"
                hwaccess: "hro"
                resval: "0"
            },
            {
                bits: "4"
                name: pue
                desc: '''
                     Pull-Up resistor Enable
                '''
                swaccess: "rw"
                hwaccess: "hro"
                resval: "0"
            },
            {
                bits: "5"
                name: rxe
                desc: '''
                     Active high RX enable
                '''
                swaccess: "rw"
                hwaccess: "hro"
                resval: "0"
            },
            {
                bits: "6"
                name: slw
                desc: '''
                     
                '''
                swaccess: "rw"
                hwaccess: "hro"
                resval: "0"
            },
            {
                bits: "7"
                name: smt
                desc: '''
                     Active High schmidt trigger Enable
                '''
                swaccess: "rw"
                hwaccess: "hro"
                resval: "0"
            },
            {
                bits: "8"
                name: trie
                desc: '''
                     Active high tri-state enable: trie = 1 -> buffer is in tri-state mode, i.e. Hi-Z. To Transmit trie = 0
                '''
                swaccess: "rw"
                hwaccess: "hro"
                resval: "1"
            },
          ]
      }

       {
          name: GPIO_17_MUX_SEL
          desc: '''
              Pad signal port multiplex selection for pad gpio_17. The programmed value defines which port
              is connected to the pad.
          '''
          swaccess: "rw"
          hwaccess: "hro"
          resval: 0
          fields: [
              {
                  bits: "3:0"
                  enum: [
                      { value: "0", name: "register", desc: "Connects the Pad to the internal configuration register."}
                      { value: "1", name: "port_i2c0_scl", desc: "Connect port scl from port group i2c0 to this pad." }
                      { value: "2", name: "port_i2c0_sda", desc: "Connect port sda from port group i2c0 to this pad." }
                      { value: "3", name: "port_qspi0_csb0", desc: "Connect port csb0 from port group qspi0 to this pad." }
                      { value: "4", name: "port_qspi0_csb1", desc: "Connect port csb1 from port group qspi0 to this pad." }
                      { value: "5", name: "port_qspi0_csb2", desc: "Connect port csb2 from port group qspi0 to this pad." }
                      { value: "6", name: "port_qspi0_sck", desc: "Connect port sck from port group qspi0 to this pad." }
                      { value: "7", name: "port_qspi0_sd0", desc: "Connect port sd0 from port group qspi0 to this pad." }
                      { value: "8", name: "port_qspi0_sd1", desc: "Connect port sd1 from port group qspi0 to this pad." }
                      { value: "9", name: "port_qspi0_sd2", desc: "Connect port sd2 from port group qspi0 to this pad." }
                      { value: "10", name: "port_qspi0_sd3", desc: "Connect port sd3 from port group qspi0 to this pad." }
                      { value: "11", name: "port_uart0_rx", desc: "Connect port rx from port group uart0 to this pad." }
                      { value: "12", name: "port_uart0_tx", desc: "Connect port tx from port group uart0 to this pad." }
                  ]
              }
          ]
      }

      {
          name: GPIO_18_CFG
          desc: '''
            Pad signal configuration.
          '''
          swaccess: "rw"
          fields: [
            {
                bits: "0"
                name: chip2pad
                desc: '''
                     Signal to connect internal Chip to the TX driver of the Pad
                '''
                swaccess: "rw"
                hwaccess: "hro"
                resval: "0"
            },
            {
                bits: "2:1"
                name: drv
                desc: '''
                     Driving Strength selector
                '''
                swaccess: "rw"
                hwaccess: "hro"
                resval: "3"
            },
            {
                bits: "3"
                name: pde
                desc: '''
                     Pull-Down resistor Enable
                '''
                swaccess: "rw"
                hwaccess: "hro"
                resval: "0"
            },
            {
                bits: "4"
                name: pue
                desc: '''
                     Pull-Up resistor Enable
                '''
                swaccess: "rw"
                hwaccess: "hro"
                resval: "0"
            },
            {
                bits: "5"
                name: rxe
                desc: '''
                     Active high RX enable
                '''
                swaccess: "rw"
                hwaccess: "hro"
                resval: "0"
            },
            {
                bits: "6"
                name: slw
                desc: '''
                     
                '''
                swaccess: "rw"
                hwaccess: "hro"
                resval: "0"
            },
            {
                bits: "7"
                name: smt
                desc: '''
                     Active High schmidt trigger Enable
                '''
                swaccess: "rw"
                hwaccess: "hro"
                resval: "0"
            },
            {
                bits: "8"
                name: trie
                desc: '''
                     Active high tri-state enable: trie = 1 -> buffer is in tri-state mode, i.e. Hi-Z. To Transmit trie = 0
                '''
                swaccess: "rw"
                hwaccess: "hro"
                resval: "1"
            },
          ]
      }

       {
          name: GPIO_18_MUX_SEL
          desc: '''
              Pad signal port multiplex selection for pad gpio_18. The programmed value defines which port
              is connected to the pad.
          '''
          swaccess: "rw"
          hwaccess: "hro"
          resval: 0
          fields: [
              {
                  bits: "3:0"
                  enum: [
                      { value: "0", name: "register", desc: "Connects the Pad to the internal configuration register."}
                      { value: "1", name: "port_i2c0_scl", desc: "Connect port scl from port group i2c0 to this pad." }
                      { value: "2", name: "port_i2c0_sda", desc: "Connect port sda from port group i2c0 to this pad." }
                      { value: "3", name: "port_qspi0_csb0", desc: "Connect port csb0 from port group qspi0 to this pad." }
                      { value: "4", name: "port_qspi0_csb1", desc: "Connect port csb1 from port group qspi0 to this pad." }
                      { value: "5", name: "port_qspi0_csb2", desc: "Connect port csb2 from port group qspi0 to this pad." }
                      { value: "6", name: "port_qspi0_sck", desc: "Connect port sck from port group qspi0 to this pad." }
                      { value: "7", name: "port_qspi0_sd0", desc: "Connect port sd0 from port group qspi0 to this pad." }
                      { value: "8", name: "port_qspi0_sd1", desc: "Connect port sd1 from port group qspi0 to this pad." }
                      { value: "9", name: "port_qspi0_sd2", desc: "Connect port sd2 from port group qspi0 to this pad." }
                      { value: "10", name: "port_qspi0_sd3", desc: "Connect port sd3 from port group qspi0 to this pad." }
                      { value: "11", name: "port_uart0_rx", desc: "Connect port rx from port group uart0 to this pad." }
                      { value: "12", name: "port_uart0_tx", desc: "Connect port tx from port group uart0 to this pad." }
                  ]
              }
          ]
      }

      {
          name: GPIO_19_CFG
          desc: '''
            Pad signal configuration.
          '''
          swaccess: "rw"
          fields: [
            {
                bits: "0"
                name: chip2pad
                desc: '''
                     Signal to connect internal Chip to the TX driver of the Pad
                '''
                swaccess: "rw"
                hwaccess: "hro"
                resval: "0"
            },
            {
                bits: "2:1"
                name: drv
                desc: '''
                     Driving Strength selector
                '''
                swaccess: "rw"
                hwaccess: "hro"
                resval: "3"
            },
            {
                bits: "3"
                name: pde
                desc: '''
                     Pull-Down resistor Enable
                '''
                swaccess: "rw"
                hwaccess: "hro"
                resval: "0"
            },
            {
                bits: "4"
                name: pue
                desc: '''
                     Pull-Up resistor Enable
                '''
                swaccess: "rw"
                hwaccess: "hro"
                resval: "0"
            },
            {
                bits: "5"
                name: rxe
                desc: '''
                     Active high RX enable
                '''
                swaccess: "rw"
                hwaccess: "hro"
                resval: "0"
            },
            {
                bits: "6"
                name: slw
                desc: '''
                     
                '''
                swaccess: "rw"
                hwaccess: "hro"
                resval: "0"
            },
            {
                bits: "7"
                name: smt
                desc: '''
                     Active High schmidt trigger Enable
                '''
                swaccess: "rw"
                hwaccess: "hro"
                resval: "0"
            },
            {
                bits: "8"
                name: trie
                desc: '''
                     Active high tri-state enable: trie = 1 -> buffer is in tri-state mode, i.e. Hi-Z. To Transmit trie = 0
                '''
                swaccess: "rw"
                hwaccess: "hro"
                resval: "1"
            },
          ]
      }

       {
          name: GPIO_19_MUX_SEL
          desc: '''
              Pad signal port multiplex selection for pad gpio_19. The programmed value defines which port
              is connected to the pad.
          '''
          swaccess: "rw"
          hwaccess: "hro"
          resval: 0
          fields: [
              {
                  bits: "3:0"
                  enum: [
                      { value: "0", name: "register", desc: "Connects the Pad to the internal configuration register."}
                      { value: "1", name: "port_i2c0_scl", desc: "Connect port scl from port group i2c0 to this pad." }
                      { value: "2", name: "port_i2c0_sda", desc: "Connect port sda from port group i2c0 to this pad." }
                      { value: "3", name: "port_qspi0_csb0", desc: "Connect port csb0 from port group qspi0 to this pad." }
                      { value: "4", name: "port_qspi0_csb1", desc: "Connect port csb1 from port group qspi0 to this pad." }
                      { value: "5", name: "port_qspi0_csb2", desc: "Connect port csb2 from port group qspi0 to this pad." }
                      { value: "6", name: "port_qspi0_sck", desc: "Connect port sck from port group qspi0 to this pad." }
                      { value: "7", name: "port_qspi0_sd0", desc: "Connect port sd0 from port group qspi0 to this pad." }
                      { value: "8", name: "port_qspi0_sd1", desc: "Connect port sd1 from port group qspi0 to this pad." }
                      { value: "9", name: "port_qspi0_sd2", desc: "Connect port sd2 from port group qspi0 to this pad." }
                      { value: "10", name: "port_qspi0_sd3", desc: "Connect port sd3 from port group qspi0 to this pad." }
                      { value: "11", name: "port_uart0_rx", desc: "Connect port rx from port group uart0 to this pad." }
                      { value: "12", name: "port_uart0_tx", desc: "Connect port tx from port group uart0 to this pad." }
                  ]
              }
          ]
      }

      {
          name: GPIO_20_CFG
          desc: '''
            Pad signal configuration.
          '''
          swaccess: "rw"
          fields: [
            {
                bits: "0"
                name: chip2pad
                desc: '''
                     Signal to connect internal Chip to the TX driver of the Pad
                '''
                swaccess: "rw"
                hwaccess: "hro"
                resval: "0"
            },
            {
                bits: "2:1"
                name: drv
                desc: '''
                     Driving Strength selector
                '''
                swaccess: "rw"
                hwaccess: "hro"
                resval: "3"
            },
            {
                bits: "3"
                name: pde
                desc: '''
                     Pull-Down resistor Enable
                '''
                swaccess: "rw"
                hwaccess: "hro"
                resval: "0"
            },
            {
                bits: "4"
                name: pue
                desc: '''
                     Pull-Up resistor Enable
                '''
                swaccess: "rw"
                hwaccess: "hro"
                resval: "0"
            },
            {
                bits: "5"
                name: rxe
                desc: '''
                     Active high RX enable
                '''
                swaccess: "rw"
                hwaccess: "hro"
                resval: "0"
            },
            {
                bits: "6"
                name: slw
                desc: '''
                     
                '''
                swaccess: "rw"
                hwaccess: "hro"
                resval: "0"
            },
            {
                bits: "7"
                name: smt
                desc: '''
                     Active High schmidt trigger Enable
                '''
                swaccess: "rw"
                hwaccess: "hro"
                resval: "0"
            },
            {
                bits: "8"
                name: trie
                desc: '''
                     Active high tri-state enable: trie = 1 -> buffer is in tri-state mode, i.e. Hi-Z. To Transmit trie = 0
                '''
                swaccess: "rw"
                hwaccess: "hro"
                resval: "1"
            },
          ]
      }

       {
          name: GPIO_20_MUX_SEL
          desc: '''
              Pad signal port multiplex selection for pad gpio_20. The programmed value defines which port
              is connected to the pad.
          '''
          swaccess: "rw"
          hwaccess: "hro"
          resval: 0
          fields: [
              {
                  bits: "3:0"
                  enum: [
                      { value: "0", name: "register", desc: "Connects the Pad to the internal configuration register."}
                      { value: "1", name: "port_i2c0_scl", desc: "Connect port scl from port group i2c0 to this pad." }
                      { value: "2", name: "port_i2c0_sda", desc: "Connect port sda from port group i2c0 to this pad." }
                      { value: "3", name: "port_qspi0_csb0", desc: "Connect port csb0 from port group qspi0 to this pad." }
                      { value: "4", name: "port_qspi0_csb1", desc: "Connect port csb1 from port group qspi0 to this pad." }
                      { value: "5", name: "port_qspi0_csb2", desc: "Connect port csb2 from port group qspi0 to this pad." }
                      { value: "6", name: "port_qspi0_sck", desc: "Connect port sck from port group qspi0 to this pad." }
                      { value: "7", name: "port_qspi0_sd0", desc: "Connect port sd0 from port group qspi0 to this pad." }
                      { value: "8", name: "port_qspi0_sd1", desc: "Connect port sd1 from port group qspi0 to this pad." }
                      { value: "9", name: "port_qspi0_sd2", desc: "Connect port sd2 from port group qspi0 to this pad." }
                      { value: "10", name: "port_qspi0_sd3", desc: "Connect port sd3 from port group qspi0 to this pad." }
                      { value: "11", name: "port_uart0_rx", desc: "Connect port rx from port group uart0 to this pad." }
                      { value: "12", name: "port_uart0_tx", desc: "Connect port tx from port group uart0 to this pad." }
                  ]
              }
          ]
      }

      {
          name: GPIO_21_CFG
          desc: '''
            Pad signal configuration.
          '''
          swaccess: "rw"
          fields: [
            {
                bits: "0"
                name: chip2pad
                desc: '''
                     Signal to connect internal Chip to the TX driver of the Pad
                '''
                swaccess: "rw"
                hwaccess: "hro"
                resval: "0"
            },
            {
                bits: "2:1"
                name: drv
                desc: '''
                     Driving Strength selector
                '''
                swaccess: "rw"
                hwaccess: "hro"
                resval: "3"
            },
            {
                bits: "3"
                name: pde
                desc: '''
                     Pull-Down resistor Enable
                '''
                swaccess: "rw"
                hwaccess: "hro"
                resval: "0"
            },
            {
                bits: "4"
                name: pue
                desc: '''
                     Pull-Up resistor Enable
                '''
                swaccess: "rw"
                hwaccess: "hro"
                resval: "0"
            },
            {
                bits: "5"
                name: rxe
                desc: '''
                     Active high RX enable
                '''
                swaccess: "rw"
                hwaccess: "hro"
                resval: "0"
            },
            {
                bits: "6"
                name: slw
                desc: '''
                     
                '''
                swaccess: "rw"
                hwaccess: "hro"
                resval: "0"
            },
            {
                bits: "7"
                name: smt
                desc: '''
                     Active High schmidt trigger Enable
                '''
                swaccess: "rw"
                hwaccess: "hro"
                resval: "0"
            },
            {
                bits: "8"
                name: trie
                desc: '''
                     Active high tri-state enable: trie = 1 -> buffer is in tri-state mode, i.e. Hi-Z. To Transmit trie = 0
                '''
                swaccess: "rw"
                hwaccess: "hro"
                resval: "1"
            },
          ]
      }

       {
          name: GPIO_21_MUX_SEL
          desc: '''
              Pad signal port multiplex selection for pad gpio_21. The programmed value defines which port
              is connected to the pad.
          '''
          swaccess: "rw"
          hwaccess: "hro"
          resval: 0
          fields: [
              {
                  bits: "3:0"
                  enum: [
                      { value: "0", name: "register", desc: "Connects the Pad to the internal configuration register."}
                      { value: "1", name: "port_i2c0_scl", desc: "Connect port scl from port group i2c0 to this pad." }
                      { value: "2", name: "port_i2c0_sda", desc: "Connect port sda from port group i2c0 to this pad." }
                      { value: "3", name: "port_qspi0_csb0", desc: "Connect port csb0 from port group qspi0 to this pad." }
                      { value: "4", name: "port_qspi0_csb1", desc: "Connect port csb1 from port group qspi0 to this pad." }
                      { value: "5", name: "port_qspi0_csb2", desc: "Connect port csb2 from port group qspi0 to this pad." }
                      { value: "6", name: "port_qspi0_sck", desc: "Connect port sck from port group qspi0 to this pad." }
                      { value: "7", name: "port_qspi0_sd0", desc: "Connect port sd0 from port group qspi0 to this pad." }
                      { value: "8", name: "port_qspi0_sd1", desc: "Connect port sd1 from port group qspi0 to this pad." }
                      { value: "9", name: "port_qspi0_sd2", desc: "Connect port sd2 from port group qspi0 to this pad." }
                      { value: "10", name: "port_qspi0_sd3", desc: "Connect port sd3 from port group qspi0 to this pad." }
                      { value: "11", name: "port_uart0_rx", desc: "Connect port rx from port group uart0 to this pad." }
                      { value: "12", name: "port_uart0_tx", desc: "Connect port tx from port group uart0 to this pad." }
                  ]
              }
          ]
      }

      {
          name: GPIO_22_CFG
          desc: '''
            Pad signal configuration.
          '''
          swaccess: "rw"
          fields: [
            {
                bits: "0"
                name: chip2pad
                desc: '''
                     Signal to connect internal Chip to the TX driver of the Pad
                '''
                swaccess: "rw"
                hwaccess: "hro"
                resval: "0"
            },
            {
                bits: "2:1"
                name: drv
                desc: '''
                     Driving Strength selector
                '''
                swaccess: "rw"
                hwaccess: "hro"
                resval: "3"
            },
            {
                bits: "3"
                name: pde
                desc: '''
                     Pull-Down resistor Enable
                '''
                swaccess: "rw"
                hwaccess: "hro"
                resval: "0"
            },
            {
                bits: "4"
                name: pue
                desc: '''
                     Pull-Up resistor Enable
                '''
                swaccess: "rw"
                hwaccess: "hro"
                resval: "0"
            },
            {
                bits: "5"
                name: rxe
                desc: '''
                     Active high RX enable
                '''
                swaccess: "rw"
                hwaccess: "hro"
                resval: "0"
            },
            {
                bits: "6"
                name: slw
                desc: '''
                     
                '''
                swaccess: "rw"
                hwaccess: "hro"
                resval: "0"
            },
            {
                bits: "7"
                name: smt
                desc: '''
                     Active High schmidt trigger Enable
                '''
                swaccess: "rw"
                hwaccess: "hro"
                resval: "0"
            },
            {
                bits: "8"
                name: trie
                desc: '''
                     Active high tri-state enable: trie = 1 -> buffer is in tri-state mode, i.e. Hi-Z. To Transmit trie = 0
                '''
                swaccess: "rw"
                hwaccess: "hro"
                resval: "1"
            },
          ]
      }

       {
          name: GPIO_22_MUX_SEL
          desc: '''
              Pad signal port multiplex selection for pad gpio_22. The programmed value defines which port
              is connected to the pad.
          '''
          swaccess: "rw"
          hwaccess: "hro"
          resval: 0
          fields: [
              {
                  bits: "3:0"
                  enum: [
                      { value: "0", name: "register", desc: "Connects the Pad to the internal configuration register."}
                      { value: "1", name: "port_i2c0_scl", desc: "Connect port scl from port group i2c0 to this pad." }
                      { value: "2", name: "port_i2c0_sda", desc: "Connect port sda from port group i2c0 to this pad." }
                      { value: "3", name: "port_qspi0_csb0", desc: "Connect port csb0 from port group qspi0 to this pad." }
                      { value: "4", name: "port_qspi0_csb1", desc: "Connect port csb1 from port group qspi0 to this pad." }
                      { value: "5", name: "port_qspi0_csb2", desc: "Connect port csb2 from port group qspi0 to this pad." }
                      { value: "6", name: "port_qspi0_sck", desc: "Connect port sck from port group qspi0 to this pad." }
                      { value: "7", name: "port_qspi0_sd0", desc: "Connect port sd0 from port group qspi0 to this pad." }
                      { value: "8", name: "port_qspi0_sd1", desc: "Connect port sd1 from port group qspi0 to this pad." }
                      { value: "9", name: "port_qspi0_sd2", desc: "Connect port sd2 from port group qspi0 to this pad." }
                      { value: "10", name: "port_qspi0_sd3", desc: "Connect port sd3 from port group qspi0 to this pad." }
                      { value: "11", name: "port_uart0_rx", desc: "Connect port rx from port group uart0 to this pad." }
                      { value: "12", name: "port_uart0_tx", desc: "Connect port tx from port group uart0 to this pad." }
                  ]
              }
          ]
      }

      {
          name: GPIO_23_CFG
          desc: '''
            Pad signal configuration.
          '''
          swaccess: "rw"
          fields: [
            {
                bits: "0"
                name: chip2pad
                desc: '''
                     Signal to connect internal Chip to the TX driver of the Pad
                '''
                swaccess: "rw"
                hwaccess: "hro"
                resval: "0"
            },
            {
                bits: "2:1"
                name: drv
                desc: '''
                     Driving Strength selector
                '''
                swaccess: "rw"
                hwaccess: "hro"
                resval: "3"
            },
            {
                bits: "3"
                name: pde
                desc: '''
                     Pull-Down resistor Enable
                '''
                swaccess: "rw"
                hwaccess: "hro"
                resval: "0"
            },
            {
                bits: "4"
                name: pue
                desc: '''
                     Pull-Up resistor Enable
                '''
                swaccess: "rw"
                hwaccess: "hro"
                resval: "0"
            },
            {
                bits: "5"
                name: rxe
                desc: '''
                     Active high RX enable
                '''
                swaccess: "rw"
                hwaccess: "hro"
                resval: "0"
            },
            {
                bits: "6"
                name: slw
                desc: '''
                     
                '''
                swaccess: "rw"
                hwaccess: "hro"
                resval: "0"
            },
            {
                bits: "7"
                name: smt
                desc: '''
                     Active High schmidt trigger Enable
                '''
                swaccess: "rw"
                hwaccess: "hro"
                resval: "0"
            },
            {
                bits: "8"
                name: trie
                desc: '''
                     Active high tri-state enable: trie = 1 -> buffer is in tri-state mode, i.e. Hi-Z. To Transmit trie = 0
                '''
                swaccess: "rw"
                hwaccess: "hro"
                resval: "1"
            },
          ]
      }

       {
          name: GPIO_23_MUX_SEL
          desc: '''
              Pad signal port multiplex selection for pad gpio_23. The programmed value defines which port
              is connected to the pad.
          '''
          swaccess: "rw"
          hwaccess: "hro"
          resval: 0
          fields: [
              {
                  bits: "3:0"
                  enum: [
                      { value: "0", name: "register", desc: "Connects the Pad to the internal configuration register."}
                      { value: "1", name: "port_i2c0_scl", desc: "Connect port scl from port group i2c0 to this pad." }
                      { value: "2", name: "port_i2c0_sda", desc: "Connect port sda from port group i2c0 to this pad." }
                      { value: "3", name: "port_qspi0_csb0", desc: "Connect port csb0 from port group qspi0 to this pad." }
                      { value: "4", name: "port_qspi0_csb1", desc: "Connect port csb1 from port group qspi0 to this pad." }
                      { value: "5", name: "port_qspi0_csb2", desc: "Connect port csb2 from port group qspi0 to this pad." }
                      { value: "6", name: "port_qspi0_sck", desc: "Connect port sck from port group qspi0 to this pad." }
                      { value: "7", name: "port_qspi0_sd0", desc: "Connect port sd0 from port group qspi0 to this pad." }
                      { value: "8", name: "port_qspi0_sd1", desc: "Connect port sd1 from port group qspi0 to this pad." }
                      { value: "9", name: "port_qspi0_sd2", desc: "Connect port sd2 from port group qspi0 to this pad." }
                      { value: "10", name: "port_qspi0_sd3", desc: "Connect port sd3 from port group qspi0 to this pad." }
                      { value: "11", name: "port_uart0_rx", desc: "Connect port rx from port group uart0 to this pad." }
                      { value: "12", name: "port_uart0_tx", desc: "Connect port tx from port group uart0 to this pad." }
                  ]
              }
          ]
      }

      {
          name: GPIO_24_CFG
          desc: '''
            Pad signal configuration.
          '''
          swaccess: "rw"
          fields: [
            {
                bits: "0"
                name: chip2pad
                desc: '''
                     Signal to connect internal Chip to the TX driver of the Pad
                '''
                swaccess: "rw"
                hwaccess: "hro"
                resval: "0"
            },
            {
                bits: "2:1"
                name: drv
                desc: '''
                     Driving Strength selector
                '''
                swaccess: "rw"
                hwaccess: "hro"
                resval: "3"
            },
            {
                bits: "3"
                name: pde
                desc: '''
                     Pull-Down resistor Enable
                '''
                swaccess: "rw"
                hwaccess: "hro"
                resval: "0"
            },
            {
                bits: "4"
                name: pue
                desc: '''
                     Pull-Up resistor Enable
                '''
                swaccess: "rw"
                hwaccess: "hro"
                resval: "0"
            },
            {
                bits: "5"
                name: rxe
                desc: '''
                     Active high RX enable
                '''
                swaccess: "rw"
                hwaccess: "hro"
                resval: "0"
            },
            {
                bits: "6"
                name: slw
                desc: '''
                     
                '''
                swaccess: "rw"
                hwaccess: "hro"
                resval: "0"
            },
            {
                bits: "7"
                name: smt
                desc: '''
                     Active High schmidt trigger Enable
                '''
                swaccess: "rw"
                hwaccess: "hro"
                resval: "0"
            },
            {
                bits: "8"
                name: trie
                desc: '''
                     Active high tri-state enable: trie = 1 -> buffer is in tri-state mode, i.e. Hi-Z. To Transmit trie = 0
                '''
                swaccess: "rw"
                hwaccess: "hro"
                resval: "1"
            },
          ]
      }

       {
          name: GPIO_24_MUX_SEL
          desc: '''
              Pad signal port multiplex selection for pad gpio_24. The programmed value defines which port
              is connected to the pad.
          '''
          swaccess: "rw"
          hwaccess: "hro"
          resval: 0
          fields: [
              {
                  bits: "3:0"
                  enum: [
                      { value: "0", name: "register", desc: "Connects the Pad to the internal configuration register."}
                      { value: "1", name: "port_i2c0_scl", desc: "Connect port scl from port group i2c0 to this pad." }
                      { value: "2", name: "port_i2c0_sda", desc: "Connect port sda from port group i2c0 to this pad." }
                      { value: "3", name: "port_qspi0_csb0", desc: "Connect port csb0 from port group qspi0 to this pad." }
                      { value: "4", name: "port_qspi0_csb1", desc: "Connect port csb1 from port group qspi0 to this pad." }
                      { value: "5", name: "port_qspi0_csb2", desc: "Connect port csb2 from port group qspi0 to this pad." }
                      { value: "6", name: "port_qspi0_sck", desc: "Connect port sck from port group qspi0 to this pad." }
                      { value: "7", name: "port_qspi0_sd0", desc: "Connect port sd0 from port group qspi0 to this pad." }
                      { value: "8", name: "port_qspi0_sd1", desc: "Connect port sd1 from port group qspi0 to this pad." }
                      { value: "9", name: "port_qspi0_sd2", desc: "Connect port sd2 from port group qspi0 to this pad." }
                      { value: "10", name: "port_qspi0_sd3", desc: "Connect port sd3 from port group qspi0 to this pad." }
                      { value: "11", name: "port_uart0_rx", desc: "Connect port rx from port group uart0 to this pad." }
                      { value: "12", name: "port_uart0_tx", desc: "Connect port tx from port group uart0 to this pad." }
                  ]
              }
          ]
      }

      {
          name: GPIO_25_CFG
          desc: '''
            Pad signal configuration.
          '''
          swaccess: "rw"
          fields: [
            {
                bits: "0"
                name: chip2pad
                desc: '''
                     Signal to connect internal Chip to the TX driver of the Pad
                '''
                swaccess: "rw"
                hwaccess: "hro"
                resval: "0"
            },
            {
                bits: "2:1"
                name: drv
                desc: '''
                     Driving Strength selector
                '''
                swaccess: "rw"
                hwaccess: "hro"
                resval: "3"
            },
            {
                bits: "3"
                name: pde
                desc: '''
                     Pull-Down resistor Enable
                '''
                swaccess: "rw"
                hwaccess: "hro"
                resval: "0"
            },
            {
                bits: "4"
                name: pue
                desc: '''
                     Pull-Up resistor Enable
                '''
                swaccess: "rw"
                hwaccess: "hro"
                resval: "0"
            },
            {
                bits: "5"
                name: rxe
                desc: '''
                     Active high RX enable
                '''
                swaccess: "rw"
                hwaccess: "hro"
                resval: "0"
            },
            {
                bits: "6"
                name: slw
                desc: '''
                     
                '''
                swaccess: "rw"
                hwaccess: "hro"
                resval: "0"
            },
            {
                bits: "7"
                name: smt
                desc: '''
                     Active High schmidt trigger Enable
                '''
                swaccess: "rw"
                hwaccess: "hro"
                resval: "0"
            },
            {
                bits: "8"
                name: trie
                desc: '''
                     Active high tri-state enable: trie = 1 -> buffer is in tri-state mode, i.e. Hi-Z. To Transmit trie = 0
                '''
                swaccess: "rw"
                hwaccess: "hro"
                resval: "1"
            },
          ]
      }

       {
          name: GPIO_25_MUX_SEL
          desc: '''
              Pad signal port multiplex selection for pad gpio_25. The programmed value defines which port
              is connected to the pad.
          '''
          swaccess: "rw"
          hwaccess: "hro"
          resval: 0
          fields: [
              {
                  bits: "3:0"
                  enum: [
                      { value: "0", name: "register", desc: "Connects the Pad to the internal configuration register."}
                      { value: "1", name: "port_i2c0_scl", desc: "Connect port scl from port group i2c0 to this pad." }
                      { value: "2", name: "port_i2c0_sda", desc: "Connect port sda from port group i2c0 to this pad." }
                      { value: "3", name: "port_qspi0_csb0", desc: "Connect port csb0 from port group qspi0 to this pad." }
                      { value: "4", name: "port_qspi0_csb1", desc: "Connect port csb1 from port group qspi0 to this pad." }
                      { value: "5", name: "port_qspi0_csb2", desc: "Connect port csb2 from port group qspi0 to this pad." }
                      { value: "6", name: "port_qspi0_sck", desc: "Connect port sck from port group qspi0 to this pad." }
                      { value: "7", name: "port_qspi0_sd0", desc: "Connect port sd0 from port group qspi0 to this pad." }
                      { value: "8", name: "port_qspi0_sd1", desc: "Connect port sd1 from port group qspi0 to this pad." }
                      { value: "9", name: "port_qspi0_sd2", desc: "Connect port sd2 from port group qspi0 to this pad." }
                      { value: "10", name: "port_qspi0_sd3", desc: "Connect port sd3 from port group qspi0 to this pad." }
                      { value: "11", name: "port_uart0_rx", desc: "Connect port rx from port group uart0 to this pad." }
                      { value: "12", name: "port_uart0_tx", desc: "Connect port tx from port group uart0 to this pad." }
                  ]
              }
          ]
      }

      {
          name: GPIO_26_CFG
          desc: '''
            Pad signal configuration.
          '''
          swaccess: "rw"
          fields: [
            {
                bits: "0"
                name: chip2pad
                desc: '''
                     Signal to connect internal Chip to the TX driver of the Pad
                '''
                swaccess: "rw"
                hwaccess: "hro"
                resval: "0"
            },
            {
                bits: "2:1"
                name: drv
                desc: '''
                     Driving Strength selector
                '''
                swaccess: "rw"
                hwaccess: "hro"
                resval: "3"
            },
            {
                bits: "3"
                name: pde
                desc: '''
                     Pull-Down resistor Enable
                '''
                swaccess: "rw"
                hwaccess: "hro"
                resval: "0"
            },
            {
                bits: "4"
                name: pue
                desc: '''
                     Pull-Up resistor Enable
                '''
                swaccess: "rw"
                hwaccess: "hro"
                resval: "0"
            },
            {
                bits: "5"
                name: rxe
                desc: '''
                     Active high RX enable
                '''
                swaccess: "rw"
                hwaccess: "hro"
                resval: "0"
            },
            {
                bits: "6"
                name: slw
                desc: '''
                     
                '''
                swaccess: "rw"
                hwaccess: "hro"
                resval: "0"
            },
            {
                bits: "7"
                name: smt
                desc: '''
                     Active High schmidt trigger Enable
                '''
                swaccess: "rw"
                hwaccess: "hro"
                resval: "0"
            },
            {
                bits: "8"
                name: trie
                desc: '''
                     Active high tri-state enable: trie = 1 -> buffer is in tri-state mode, i.e. Hi-Z. To Transmit trie = 0
                '''
                swaccess: "rw"
                hwaccess: "hro"
                resval: "1"
            },
          ]
      }

       {
          name: GPIO_26_MUX_SEL
          desc: '''
              Pad signal port multiplex selection for pad gpio_26. The programmed value defines which port
              is connected to the pad.
          '''
          swaccess: "rw"
          hwaccess: "hro"
          resval: 0
          fields: [
              {
                  bits: "3:0"
                  enum: [
                      { value: "0", name: "register", desc: "Connects the Pad to the internal configuration register."}
                      { value: "1", name: "port_i2c0_scl", desc: "Connect port scl from port group i2c0 to this pad." }
                      { value: "2", name: "port_i2c0_sda", desc: "Connect port sda from port group i2c0 to this pad." }
                      { value: "3", name: "port_qspi0_csb0", desc: "Connect port csb0 from port group qspi0 to this pad." }
                      { value: "4", name: "port_qspi0_csb1", desc: "Connect port csb1 from port group qspi0 to this pad." }
                      { value: "5", name: "port_qspi0_csb2", desc: "Connect port csb2 from port group qspi0 to this pad." }
                      { value: "6", name: "port_qspi0_sck", desc: "Connect port sck from port group qspi0 to this pad." }
                      { value: "7", name: "port_qspi0_sd0", desc: "Connect port sd0 from port group qspi0 to this pad." }
                      { value: "8", name: "port_qspi0_sd1", desc: "Connect port sd1 from port group qspi0 to this pad." }
                      { value: "9", name: "port_qspi0_sd2", desc: "Connect port sd2 from port group qspi0 to this pad." }
                      { value: "10", name: "port_qspi0_sd3", desc: "Connect port sd3 from port group qspi0 to this pad." }
                      { value: "11", name: "port_uart0_rx", desc: "Connect port rx from port group uart0 to this pad." }
                      { value: "12", name: "port_uart0_tx", desc: "Connect port tx from port group uart0 to this pad." }
                  ]
              }
          ]
      }

      {
          name: GPIO_27_CFG
          desc: '''
            Pad signal configuration.
          '''
          swaccess: "rw"
          fields: [
            {
                bits: "0"
                name: chip2pad
                desc: '''
                     Signal to connect internal Chip to the TX driver of the Pad
                '''
                swaccess: "rw"
                hwaccess: "hro"
                resval: "0"
            },
            {
                bits: "2:1"
                name: drv
                desc: '''
                     Driving Strength selector
                '''
                swaccess: "rw"
                hwaccess: "hro"
                resval: "3"
            },
            {
                bits: "3"
                name: pde
                desc: '''
                     Pull-Down resistor Enable
                '''
                swaccess: "rw"
                hwaccess: "hro"
                resval: "0"
            },
            {
                bits: "4"
                name: pue
                desc: '''
                     Pull-Up resistor Enable
                '''
                swaccess: "rw"
                hwaccess: "hro"
                resval: "0"
            },
            {
                bits: "5"
                name: rxe
                desc: '''
                     Active high RX enable
                '''
                swaccess: "rw"
                hwaccess: "hro"
                resval: "0"
            },
            {
                bits: "6"
                name: slw
                desc: '''
                     
                '''
                swaccess: "rw"
                hwaccess: "hro"
                resval: "0"
            },
            {
                bits: "7"
                name: smt
                desc: '''
                     Active High schmidt trigger Enable
                '''
                swaccess: "rw"
                hwaccess: "hro"
                resval: "0"
            },
            {
                bits: "8"
                name: trie
                desc: '''
                     Active high tri-state enable: trie = 1 -> buffer is in tri-state mode, i.e. Hi-Z. To Transmit trie = 0
                '''
                swaccess: "rw"
                hwaccess: "hro"
                resval: "1"
            },
          ]
      }

       {
          name: GPIO_27_MUX_SEL
          desc: '''
              Pad signal port multiplex selection for pad gpio_27. The programmed value defines which port
              is connected to the pad.
          '''
          swaccess: "rw"
          hwaccess: "hro"
          resval: 0
          fields: [
              {
                  bits: "3:0"
                  enum: [
                      { value: "0", name: "register", desc: "Connects the Pad to the internal configuration register."}
                      { value: "1", name: "port_i2c0_scl", desc: "Connect port scl from port group i2c0 to this pad." }
                      { value: "2", name: "port_i2c0_sda", desc: "Connect port sda from port group i2c0 to this pad." }
                      { value: "3", name: "port_qspi0_csb0", desc: "Connect port csb0 from port group qspi0 to this pad." }
                      { value: "4", name: "port_qspi0_csb1", desc: "Connect port csb1 from port group qspi0 to this pad." }
                      { value: "5", name: "port_qspi0_csb2", desc: "Connect port csb2 from port group qspi0 to this pad." }
                      { value: "6", name: "port_qspi0_sck", desc: "Connect port sck from port group qspi0 to this pad." }
                      { value: "7", name: "port_qspi0_sd0", desc: "Connect port sd0 from port group qspi0 to this pad." }
                      { value: "8", name: "port_qspi0_sd1", desc: "Connect port sd1 from port group qspi0 to this pad." }
                      { value: "9", name: "port_qspi0_sd2", desc: "Connect port sd2 from port group qspi0 to this pad." }
                      { value: "10", name: "port_qspi0_sd3", desc: "Connect port sd3 from port group qspi0 to this pad." }
                      { value: "11", name: "port_uart0_rx", desc: "Connect port rx from port group uart0 to this pad." }
                      { value: "12", name: "port_uart0_tx", desc: "Connect port tx from port group uart0 to this pad." }
                  ]
              }
          ]
      }

      {
          name: GPIO_28_CFG
          desc: '''
            Pad signal configuration.
          '''
          swaccess: "rw"
          fields: [
            {
                bits: "0"
                name: chip2pad
                desc: '''
                     Signal to connect internal Chip to the TX driver of the Pad
                '''
                swaccess: "rw"
                hwaccess: "hro"
                resval: "0"
            },
            {
                bits: "2:1"
                name: drv
                desc: '''
                     Driving Strength selector
                '''
                swaccess: "rw"
                hwaccess: "hro"
                resval: "3"
            },
            {
                bits: "3"
                name: pde
                desc: '''
                     Pull-Down resistor Enable
                '''
                swaccess: "rw"
                hwaccess: "hro"
                resval: "0"
            },
            {
                bits: "4"
                name: pue
                desc: '''
                     Pull-Up resistor Enable
                '''
                swaccess: "rw"
                hwaccess: "hro"
                resval: "0"
            },
            {
                bits: "5"
                name: rxe
                desc: '''
                     Active high RX enable
                '''
                swaccess: "rw"
                hwaccess: "hro"
                resval: "0"
            },
            {
                bits: "6"
                name: slw
                desc: '''
                     
                '''
                swaccess: "rw"
                hwaccess: "hro"
                resval: "0"
            },
            {
                bits: "7"
                name: smt
                desc: '''
                     Active High schmidt trigger Enable
                '''
                swaccess: "rw"
                hwaccess: "hro"
                resval: "0"
            },
            {
                bits: "8"
                name: trie
                desc: '''
                     Active high tri-state enable: trie = 1 -> buffer is in tri-state mode, i.e. Hi-Z. To Transmit trie = 0
                '''
                swaccess: "rw"
                hwaccess: "hro"
                resval: "1"
            },
          ]
      }

       {
          name: GPIO_28_MUX_SEL
          desc: '''
              Pad signal port multiplex selection for pad gpio_28. The programmed value defines which port
              is connected to the pad.
          '''
          swaccess: "rw"
          hwaccess: "hro"
          resval: 0
          fields: [
              {
                  bits: "3:0"
                  enum: [
                      { value: "0", name: "register", desc: "Connects the Pad to the internal configuration register."}
                      { value: "1", name: "port_i2c0_scl", desc: "Connect port scl from port group i2c0 to this pad." }
                      { value: "2", name: "port_i2c0_sda", desc: "Connect port sda from port group i2c0 to this pad." }
                      { value: "3", name: "port_qspi0_csb0", desc: "Connect port csb0 from port group qspi0 to this pad." }
                      { value: "4", name: "port_qspi0_csb1", desc: "Connect port csb1 from port group qspi0 to this pad." }
                      { value: "5", name: "port_qspi0_csb2", desc: "Connect port csb2 from port group qspi0 to this pad." }
                      { value: "6", name: "port_qspi0_sck", desc: "Connect port sck from port group qspi0 to this pad." }
                      { value: "7", name: "port_qspi0_sd0", desc: "Connect port sd0 from port group qspi0 to this pad." }
                      { value: "8", name: "port_qspi0_sd1", desc: "Connect port sd1 from port group qspi0 to this pad." }
                      { value: "9", name: "port_qspi0_sd2", desc: "Connect port sd2 from port group qspi0 to this pad." }
                      { value: "10", name: "port_qspi0_sd3", desc: "Connect port sd3 from port group qspi0 to this pad." }
                      { value: "11", name: "port_uart0_rx", desc: "Connect port rx from port group uart0 to this pad." }
                      { value: "12", name: "port_uart0_tx", desc: "Connect port tx from port group uart0 to this pad." }
                  ]
              }
          ]
      }

      {
          name: GPIO_29_CFG
          desc: '''
            Pad signal configuration.
          '''
          swaccess: "rw"
          fields: [
            {
                bits: "0"
                name: chip2pad
                desc: '''
                     Signal to connect internal Chip to the TX driver of the Pad
                '''
                swaccess: "rw"
                hwaccess: "hro"
                resval: "0"
            },
            {
                bits: "2:1"
                name: drv
                desc: '''
                     Driving Strength selector
                '''
                swaccess: "rw"
                hwaccess: "hro"
                resval: "3"
            },
            {
                bits: "3"
                name: pde
                desc: '''
                     Pull-Down resistor Enable
                '''
                swaccess: "rw"
                hwaccess: "hro"
                resval: "0"
            },
            {
                bits: "4"
                name: pue
                desc: '''
                     Pull-Up resistor Enable
                '''
                swaccess: "rw"
                hwaccess: "hro"
                resval: "0"
            },
            {
                bits: "5"
                name: rxe
                desc: '''
                     Active high RX enable
                '''
                swaccess: "rw"
                hwaccess: "hro"
                resval: "0"
            },
            {
                bits: "6"
                name: slw
                desc: '''
                     
                '''
                swaccess: "rw"
                hwaccess: "hro"
                resval: "0"
            },
            {
                bits: "7"
                name: smt
                desc: '''
                     Active High schmidt trigger Enable
                '''
                swaccess: "rw"
                hwaccess: "hro"
                resval: "0"
            },
            {
                bits: "8"
                name: trie
                desc: '''
                     Active high tri-state enable: trie = 1 -> buffer is in tri-state mode, i.e. Hi-Z. To Transmit trie = 0
                '''
                swaccess: "rw"
                hwaccess: "hro"
                resval: "1"
            },
          ]
      }

       {
          name: GPIO_29_MUX_SEL
          desc: '''
              Pad signal port multiplex selection for pad gpio_29. The programmed value defines which port
              is connected to the pad.
          '''
          swaccess: "rw"
          hwaccess: "hro"
          resval: 0
          fields: [
              {
                  bits: "3:0"
                  enum: [
                      { value: "0", name: "register", desc: "Connects the Pad to the internal configuration register."}
                      { value: "1", name: "port_i2c0_scl", desc: "Connect port scl from port group i2c0 to this pad." }
                      { value: "2", name: "port_i2c0_sda", desc: "Connect port sda from port group i2c0 to this pad." }
                      { value: "3", name: "port_qspi0_csb0", desc: "Connect port csb0 from port group qspi0 to this pad." }
                      { value: "4", name: "port_qspi0_csb1", desc: "Connect port csb1 from port group qspi0 to this pad." }
                      { value: "5", name: "port_qspi0_csb2", desc: "Connect port csb2 from port group qspi0 to this pad." }
                      { value: "6", name: "port_qspi0_sck", desc: "Connect port sck from port group qspi0 to this pad." }
                      { value: "7", name: "port_qspi0_sd0", desc: "Connect port sd0 from port group qspi0 to this pad." }
                      { value: "8", name: "port_qspi0_sd1", desc: "Connect port sd1 from port group qspi0 to this pad." }
                      { value: "9", name: "port_qspi0_sd2", desc: "Connect port sd2 from port group qspi0 to this pad." }
                      { value: "10", name: "port_qspi0_sd3", desc: "Connect port sd3 from port group qspi0 to this pad." }
                      { value: "11", name: "port_uart0_rx", desc: "Connect port rx from port group uart0 to this pad." }
                      { value: "12", name: "port_uart0_tx", desc: "Connect port tx from port group uart0 to this pad." }
                  ]
              }
          ]
      }

      {
          name: GPIO_30_CFG
          desc: '''
            Pad signal configuration.
          '''
          swaccess: "rw"
          fields: [
            {
                bits: "0"
                name: chip2pad
                desc: '''
                     Signal to connect internal Chip to the TX driver of the Pad
                '''
                swaccess: "rw"
                hwaccess: "hro"
                resval: "0"
            },
            {
                bits: "2:1"
                name: drv
                desc: '''
                     Driving Strength selector
                '''
                swaccess: "rw"
                hwaccess: "hro"
                resval: "3"
            },
            {
                bits: "3"
                name: pde
                desc: '''
                     Pull-Down resistor Enable
                '''
                swaccess: "rw"
                hwaccess: "hro"
                resval: "0"
            },
            {
                bits: "4"
                name: pue
                desc: '''
                     Pull-Up resistor Enable
                '''
                swaccess: "rw"
                hwaccess: "hro"
                resval: "0"
            },
            {
                bits: "5"
                name: rxe
                desc: '''
                     Active high RX enable
                '''
                swaccess: "rw"
                hwaccess: "hro"
                resval: "0"
            },
            {
                bits: "6"
                name: slw
                desc: '''
                     
                '''
                swaccess: "rw"
                hwaccess: "hro"
                resval: "0"
            },
            {
                bits: "7"
                name: smt
                desc: '''
                     Active High schmidt trigger Enable
                '''
                swaccess: "rw"
                hwaccess: "hro"
                resval: "0"
            },
            {
                bits: "8"
                name: trie
                desc: '''
                     Active high tri-state enable: trie = 1 -> buffer is in tri-state mode, i.e. Hi-Z. To Transmit trie = 0
                '''
                swaccess: "rw"
                hwaccess: "hro"
                resval: "1"
            },
          ]
      }

       {
          name: GPIO_30_MUX_SEL
          desc: '''
              Pad signal port multiplex selection for pad gpio_30. The programmed value defines which port
              is connected to the pad.
          '''
          swaccess: "rw"
          hwaccess: "hro"
          resval: 0
          fields: [
              {
                  bits: "3:0"
                  enum: [
                      { value: "0", name: "register", desc: "Connects the Pad to the internal configuration register."}
                      { value: "1", name: "port_i2c0_scl", desc: "Connect port scl from port group i2c0 to this pad." }
                      { value: "2", name: "port_i2c0_sda", desc: "Connect port sda from port group i2c0 to this pad." }
                      { value: "3", name: "port_qspi0_csb0", desc: "Connect port csb0 from port group qspi0 to this pad." }
                      { value: "4", name: "port_qspi0_csb1", desc: "Connect port csb1 from port group qspi0 to this pad." }
                      { value: "5", name: "port_qspi0_csb2", desc: "Connect port csb2 from port group qspi0 to this pad." }
                      { value: "6", name: "port_qspi0_sck", desc: "Connect port sck from port group qspi0 to this pad." }
                      { value: "7", name: "port_qspi0_sd0", desc: "Connect port sd0 from port group qspi0 to this pad." }
                      { value: "8", name: "port_qspi0_sd1", desc: "Connect port sd1 from port group qspi0 to this pad." }
                      { value: "9", name: "port_qspi0_sd2", desc: "Connect port sd2 from port group qspi0 to this pad." }
                      { value: "10", name: "port_qspi0_sd3", desc: "Connect port sd3 from port group qspi0 to this pad." }
                      { value: "11", name: "port_uart0_rx", desc: "Connect port rx from port group uart0 to this pad." }
                      { value: "12", name: "port_uart0_tx", desc: "Connect port tx from port group uart0 to this pad." }
                  ]
              }
          ]
      }

      {
          name: GPIO_31_CFG
          desc: '''
            Pad signal configuration.
          '''
          swaccess: "rw"
          fields: [
            {
                bits: "0"
                name: chip2pad
                desc: '''
                     Signal to connect internal Chip to the TX driver of the Pad
                '''
                swaccess: "rw"
                hwaccess: "hro"
                resval: "0"
            },
            {
                bits: "2:1"
                name: drv
                desc: '''
                     Driving Strength selector
                '''
                swaccess: "rw"
                hwaccess: "hro"
                resval: "3"
            },
            {
                bits: "3"
                name: pde
                desc: '''
                     Pull-Down resistor Enable
                '''
                swaccess: "rw"
                hwaccess: "hro"
                resval: "0"
            },
            {
                bits: "4"
                name: pue
                desc: '''
                     Pull-Up resistor Enable
                '''
                swaccess: "rw"
                hwaccess: "hro"
                resval: "0"
            },
            {
                bits: "5"
                name: rxe
                desc: '''
                     Active high RX enable
                '''
                swaccess: "rw"
                hwaccess: "hro"
                resval: "0"
            },
            {
                bits: "6"
                name: slw
                desc: '''
                     
                '''
                swaccess: "rw"
                hwaccess: "hro"
                resval: "0"
            },
            {
                bits: "7"
                name: smt
                desc: '''
                     Active High schmidt trigger Enable
                '''
                swaccess: "rw"
                hwaccess: "hro"
                resval: "0"
            },
            {
                bits: "8"
                name: trie
                desc: '''
                     Active high tri-state enable: trie = 1 -> buffer is in tri-state mode, i.e. Hi-Z. To Transmit trie = 0
                '''
                swaccess: "rw"
                hwaccess: "hro"
                resval: "1"
            },
          ]
      }

       {
          name: GPIO_31_MUX_SEL
          desc: '''
              Pad signal port multiplex selection for pad gpio_31. The programmed value defines which port
              is connected to the pad.
          '''
          swaccess: "rw"
          hwaccess: "hro"
          resval: 0
          fields: [
              {
                  bits: "5:0"
                  enum: [
                      { value: "0", name: "register", desc: "Connects the Pad to the internal configuration register."}
                      { value: "1", name: "port_gpioa0_gpio", desc: "Connect port gpio from port group gpioa0 to this pad." }
                      { value: "2", name: "port_gpioa1_gpio", desc: "Connect port gpio from port group gpioa1 to this pad." }
                      { value: "3", name: "port_gpioa2_gpio", desc: "Connect port gpio from port group gpioa2 to this pad." }
                      { value: "4", name: "port_gpioa3_gpio", desc: "Connect port gpio from port group gpioa3 to this pad." }
                      { value: "5", name: "port_gpioa4_gpio", desc: "Connect port gpio from port group gpioa4 to this pad." }
                      { value: "6", name: "port_gpioa5_gpio", desc: "Connect port gpio from port group gpioa5 to this pad." }
                      { value: "7", name: "port_gpioa6_gpio", desc: "Connect port gpio from port group gpioa6 to this pad." }
                      { value: "8", name: "port_gpioa7_gpio", desc: "Connect port gpio from port group gpioa7 to this pad." }
                      { value: "9", name: "port_gpioa8_gpio", desc: "Connect port gpio from port group gpioa8 to this pad." }
                      { value: "10", name: "port_gpioa9_gpio", desc: "Connect port gpio from port group gpioa9 to this pad." }
                      { value: "11", name: "port_gpioa10_gpio", desc: "Connect port gpio from port group gpioa10 to this pad." }
                      { value: "12", name: "port_gpioa11_gpio", desc: "Connect port gpio from port group gpioa11 to this pad." }
                      { value: "13", name: "port_gpioa12_gpio", desc: "Connect port gpio from port group gpioa12 to this pad." }
                      { value: "14", name: "port_gpioa13_gpio", desc: "Connect port gpio from port group gpioa13 to this pad." }
                      { value: "15", name: "port_gpioa14_gpio", desc: "Connect port gpio from port group gpioa14 to this pad." }
                      { value: "16", name: "port_gpioa15_gpio", desc: "Connect port gpio from port group gpioa15 to this pad." }
                      { value: "17", name: "port_gpioa16_gpio", desc: "Connect port gpio from port group gpioa16 to this pad." }
                      { value: "18", name: "port_gpioa17_gpio", desc: "Connect port gpio from port group gpioa17 to this pad." }
                      { value: "19", name: "port_gpioa18_gpio", desc: "Connect port gpio from port group gpioa18 to this pad." }
                      { value: "20", name: "port_gpioa19_gpio", desc: "Connect port gpio from port group gpioa19 to this pad." }
                      { value: "21", name: "port_gpioa20_gpio", desc: "Connect port gpio from port group gpioa20 to this pad." }
                      { value: "22", name: "port_gpioa21_gpio", desc: "Connect port gpio from port group gpioa21 to this pad." }
                      { value: "23", name: "port_gpioa22_gpio", desc: "Connect port gpio from port group gpioa22 to this pad." }
                      { value: "24", name: "port_gpioa23_gpio", desc: "Connect port gpio from port group gpioa23 to this pad." }
                      { value: "25", name: "port_gpioa24_gpio", desc: "Connect port gpio from port group gpioa24 to this pad." }
                      { value: "26", name: "port_gpioa25_gpio", desc: "Connect port gpio from port group gpioa25 to this pad." }
                      { value: "27", name: "port_gpioa26_gpio", desc: "Connect port gpio from port group gpioa26 to this pad." }
                      { value: "28", name: "port_gpioa27_gpio", desc: "Connect port gpio from port group gpioa27 to this pad." }
                      { value: "29", name: "port_gpioa28_gpio", desc: "Connect port gpio from port group gpioa28 to this pad." }
                      { value: "30", name: "port_gpioa29_gpio", desc: "Connect port gpio from port group gpioa29 to this pad." }
                      { value: "31", name: "port_gpioa30_gpio", desc: "Connect port gpio from port group gpioa30 to this pad." }
                      { value: "32", name: "port_gpioa31_gpio", desc: "Connect port gpio from port group gpioa31 to this pad." }
                      { value: "33", name: "port_i2c0_scl", desc: "Connect port scl from port group i2c0 to this pad." }
                      { value: "34", name: "port_i2c0_sda", desc: "Connect port sda from port group i2c0 to this pad." }
                      { value: "35", name: "port_qspi0_csb0", desc: "Connect port csb0 from port group qspi0 to this pad." }
                      { value: "36", name: "port_qspi0_csb1", desc: "Connect port csb1 from port group qspi0 to this pad." }
                      { value: "37", name: "port_qspi0_csb2", desc: "Connect port csb2 from port group qspi0 to this pad." }
                      { value: "38", name: "port_qspi0_sck", desc: "Connect port sck from port group qspi0 to this pad." }
                      { value: "39", name: "port_qspi0_sd0", desc: "Connect port sd0 from port group qspi0 to this pad." }
                      { value: "40", name: "port_qspi0_sd1", desc: "Connect port sd1 from port group qspi0 to this pad." }
                      { value: "41", name: "port_qspi0_sd2", desc: "Connect port sd2 from port group qspi0 to this pad." }
                      { value: "42", name: "port_qspi0_sd3", desc: "Connect port sd3 from port group qspi0 to this pad." }
                      { value: "43", name: "port_uart0_rx", desc: "Connect port rx from port group uart0 to this pad." }
                      { value: "44", name: "port_uart0_tx", desc: "Connect port tx from port group uart0 to this pad." }
                  ]
              }
          ]
      }

    ]
}
